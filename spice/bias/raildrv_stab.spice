* What do the ve and vrefb rails actually have to DRIVE?
*
* UNPLACED.md and raildrv (ptat_bias.inc:94) both use ota2b for BOTH rails,
* as though they were the same kind of load.  They are not:
*   vrefb is high-Z -- two ota1vb `inn` gates and two bleed resistors per cell
*   ve    is the NPN EMITTER node (QQA/QQB) and the ota1vb `vss` rail, so it
*         sinks real DC current
* This deck holds both rails with voltage sources across a 2-cell chain and
* measures the current each one actually carries, so raildrv can be sized on
* evidence rather than on the assumption that one buffer fits both.
*
* Run: ngspice -b ve_load.spice
.lib /Users/cteusche/.ciel/sky130A/libs.tech/ngspice/sky130.lib.spice tt

VDD vdd 0 3.3

* pbias: diode-connected PMOS fed by a 2 uA sink.  The sink must pull OUT of
* the node -- `IB vdd pb 2u` pushes current IN, parks pb at ~3.97 V on a 3.3 V
* rail and turns the mirror off.  That error once produced a sigma ~100x the
* physical value in this tree.
IB pb 0 2u
XPB pb pb vdd vdd sky130_fd_pr__pfet_g5v0d10v5 W=16 L=8

* the two rails, held ideally so their current is readable
XDRV ve nd055 vdd pb raildrv
* vrefb is no longer buffered (one-buffer raildrv, 2026-07-29):
* it IS the divider tap.
RVRB nd12 vrefb 0.001
VND12 nd12 0 1.2
VND55 nd055 0 0.55

* a 2-cell chain's worth of load
XCELLA nua nva outa vdd vrefb ve pb emlcell_b
XCELLB nub nvb outb vdd vrefb ve pb emlcell_b
IVA 0 nva 0.5u
ISTEP ve 0 PULSE(0 10u 20u 20n 20n 60u 200u)
IVB 0 nvb 0.5u
VOUTA outa 0 0.9
VOUTB outb 0 0.9

.include /Users/cteusche/data/projects/eml/code/silicon/bias/ptat_bias.inc
.include /Users/cteusche/data/projects/eml/code/silicon/cell/v3/eml_cell_v3b.inc

.control
set filetype=ascii
tran 0.2u 120u
echo "--- step response: 10uA load step on ve at t=20us ---"
meas tran vemin  MIN v(ve) from=20u to=60u
meas tran vemax  MAX v(ve) from=20u to=60u
meas tran vesettle AVG v(ve) from=50u to=60u
meas tran vrbmin MIN v(vrefb) from=20u to=60u
meas tran vrbmax MAX v(vrefb) from=20u to=60u
echo "--- rail voltages held at ---"
* how far do the rails move if the buffer has a finite output impedance?
* 1 kohm in series is a stand-in for a weak follower.
.endc
.end
