* NGSPICE file created from rptat_trim.ext - technology: sky130A

.subckt rptat_trim
X0 a_2313_1550.t1 n2.t1 VSUB.t4 sky130_fd_pr__res_high_po_0p35 l=5.47
X1 n3.t0 t1 n2.t0 VSUB.t0 sky130_fd_pr__nfet_g5v0d10v5 ad=8.8 pd=17.1 as=8.8 ps=17.1 w=16 l=0.5
X2 VSUB.t7 t2 n3.t2 VSUB.t6 sky130_fd_pr__nfet_g5v0d10v5 ad=17.6 pd=34.2 as=8.8 ps=17.1 w=16 l=0.5
X3 n2.t2 n1.t1 VSUB.t5 sky130_fd_pr__res_high_po_0p35 l=5.47
X4 a_297_1550.t1 ne2.t0 VSUB.t13 sky130_fd_pr__res_high_po_0p35 l=5.47
X5 a_3321_1550.t1 n3.t3 VSUB.t14 sky130_fd_pr__res_high_po_0p35 l=5.47
X6 n3.t1 a_2313_1550.t0 VSUB.t2 sky130_fd_pr__res_high_po_0p35 l=5.47
X7 a_4329_1550.t1 a_3825_1550.t0 VSUB.t11 sky130_fd_pr__res_high_po_0p35 l=5.47
X8 a_3825_1550.t1 a_3321_1550.t0 VSUB.t12 sky130_fd_pr__res_high_po_0p35 l=5.47
X9 VSUB.t10 a_4329_1550.t0 VSUB.t9 sky130_fd_pr__res_high_po_0p35 l=5.47
X10 a_801_1550.t1 a_297_1550.t0 VSUB.t3 sky130_fd_pr__res_high_po_0p35 l=5.47
X11 n2.t3 t0 n1.t2 VSUB.t8 sky130_fd_pr__nfet_g5v0d10v5 ad=8.8 pd=17.1 as=17.6 ps=34.2 w=16 l=0.5
X12 n1.t0 a_801_1550.t0 VSUB.t1 sky130_fd_pr__res_high_po_0p35 l=5.47
R0 a_4329_1550.t0 a_4329_1550.t1 37.2461
R1 a_3825_1550.t0 a_3825_1550.t1 37.2461
R2 a_3321_1550.t0 a_3321_1550.t1 37.2461
R3 n3.n0 n3.t1 20.0749
R4 n3.n0 n3.t3 17.1582
R5 n3 n3.n1 14.5257
R6 n3 n3.n0 8.99167
R7 n3.n1 n3.t2 3.91925
R8 n3.n1 n3.t0 3.91925
R9 a_2313_1550.t0 a_2313_1550.t1 37.2461
R10 n2.n0 n2.t2 20.0749
R11 n2.n0 n2.t1 17.1582
R12 n2 n2.n1 14.2132
R13 n2 n2.n0 8.22917
R14 n2.n1 n2.t0 3.91925
R15 n2.n1 n2.t3 3.91925
R16 n1.n0 n1.t0 20.0749
R17 n1 n1.t2 17.8195
R18 n1.n0 n1.t1 17.1582
R19 n1 n1.n0 8.25417
R20 a_801_1550.t0 a_801_1550.t1 37.2461
R21 ne2 ne2.t0 17.4124
R22 a_297_1550.t0 a_297_1550.t1 37.2461
R23 VSUB.n129 VSUB.n128 666.141
R24 VSUB.n71 VSUB.n41 666.141
R25 VSUB.n145 VSUB.n144 589.355
R26 VSUB.n147 VSUB.n145 585
R27 VSUB.n150 VSUB.n149 585
R28 VSUB.n149 VSUB.n148 585
R29 VSUB.n151 VSUB.n140 585
R30 VSUB.n140 VSUB.n139 585
R31 VSUB.n153 VSUB.n152 585
R32 VSUB.n154 VSUB.n153 585
R33 VSUB.n138 VSUB.n137 585
R34 VSUB.n155 VSUB.n138 585
R35 VSUB.n157 VSUB.n156 585
R36 VSUB.n156 VSUB.t0 585
R37 VSUB.n158 VSUB.n133 585
R38 VSUB.n133 VSUB.n132 585
R39 VSUB.n160 VSUB.n159 585
R40 VSUB.n161 VSUB.n160 585
R41 VSUB.n27 VSUB.n25 585
R42 VSUB.n162 VSUB.n27 585
R43 VSUB.n165 VSUB.n164 585
R44 VSUB.n164 VSUB.n163 585
R45 VSUB.n26 VSUB.n23 585
R46 VSUB.n131 VSUB.n26 585
R47 VSUB.n44 VSUB.n43 585
R48 VSUB.n126 VSUB.n42 585
R49 VSUB.n130 VSUB.n42 585
R50 VSUB.n125 VSUB.n124 585
R51 VSUB.n123 VSUB.n122 585
R52 VSUB.n121 VSUB.n120 585
R53 VSUB.n119 VSUB.n118 585
R54 VSUB.n117 VSUB.n116 585
R55 VSUB.n115 VSUB.n114 585
R56 VSUB.n113 VSUB.n112 585
R57 VSUB.n111 VSUB.n110 585
R58 VSUB.n109 VSUB.n108 585
R59 VSUB.n107 VSUB.n106 585
R60 VSUB.n105 VSUB.n104 585
R61 VSUB.n103 VSUB.n102 585
R62 VSUB.n101 VSUB.n100 585
R63 VSUB.n99 VSUB.n98 585
R64 VSUB.n97 VSUB.n96 585
R65 VSUB.n95 VSUB.n94 585
R66 VSUB.n93 VSUB.n92 585
R67 VSUB.n91 VSUB.n90 585
R68 VSUB.n89 VSUB.n88 585
R69 VSUB.n87 VSUB.n86 585
R70 VSUB.n85 VSUB.n84 585
R71 VSUB.n83 VSUB.n82 585
R72 VSUB.n81 VSUB.n80 585
R73 VSUB.n79 VSUB.n78 585
R74 VSUB.n77 VSUB.n76 585
R75 VSUB.n75 VSUB.n74 585
R76 VSUB.n73 VSUB.n72 585
R77 VSUB.t11 VSUB.t9 299.353
R78 VSUB.t12 VSUB.t11 299.353
R79 VSUB.t14 VSUB.t12 299.353
R80 VSUB.t2 VSUB.t14 299.353
R81 VSUB.t4 VSUB.t2 299.353
R82 VSUB.t5 VSUB.t4 299.353
R83 VSUB.n130 VSUB.n129 254.044
R84 VSUB.n130 VSUB.n28 254.044
R85 VSUB.n130 VSUB.n29 254.044
R86 VSUB.n130 VSUB.n30 254.044
R87 VSUB.n130 VSUB.n31 254.044
R88 VSUB.n130 VSUB.n32 254.044
R89 VSUB.n130 VSUB.n33 254.044
R90 VSUB.n130 VSUB.n34 254.044
R91 VSUB.n130 VSUB.n35 254.044
R92 VSUB.n130 VSUB.n36 254.044
R93 VSUB.n130 VSUB.n37 254.044
R94 VSUB.n130 VSUB.n38 254.044
R95 VSUB.n130 VSUB.n39 254.044
R96 VSUB.n130 VSUB.n40 254.044
R97 VSUB.n130 VSUB.n41 254.044
R98 VSUB.n164 VSUB.n26 197
R99 VSUB.n164 VSUB.n27 197
R100 VSUB.n160 VSUB.n27 197
R101 VSUB.n160 VSUB.n133 197
R102 VSUB.n156 VSUB.n133 197
R103 VSUB.n156 VSUB.n138 197
R104 VSUB.n153 VSUB.n138 197
R105 VSUB.n153 VSUB.n140 197
R106 VSUB.n149 VSUB.n140 197
R107 VSUB.n149 VSUB.n145 197
R108 VSUB.n220 VSUB.n1 185
R109 VSUB.n130 VSUB.t5 183.531
R110 VSUB.n43 VSUB.n42 177.109
R111 VSUB.n124 VSUB.n42 177.109
R112 VSUB.n122 VSUB.n121 177.109
R113 VSUB.n118 VSUB.n117 177.109
R114 VSUB.n114 VSUB.n113 177.109
R115 VSUB.n110 VSUB.n109 177.109
R116 VSUB.n106 VSUB.n105 177.109
R117 VSUB.n102 VSUB.n101 177.109
R118 VSUB.n98 VSUB.n97 177.109
R119 VSUB.n94 VSUB.n93 177.109
R120 VSUB.n90 VSUB.n89 177.109
R121 VSUB.n86 VSUB.n85 177.109
R122 VSUB.n82 VSUB.n81 177.109
R123 VSUB.n78 VSUB.n77 177.109
R124 VSUB.n74 VSUB.n73 177.109
R125 VSUB.n147 VSUB.n146 117.603
R126 VSUB.t1 VSUB.n130 115.822
R127 VSUB.n218 VSUB.n1 88.4738
R128 VSUB.n4 VSUB.n1 88.4738
R129 VSUB.n211 VSUB.n1 88.4738
R130 VSUB.n7 VSUB.n1 88.4738
R131 VSUB.n204 VSUB.n1 88.4738
R132 VSUB.n10 VSUB.n1 88.4738
R133 VSUB.n197 VSUB.n1 88.4738
R134 VSUB.n13 VSUB.n1 88.4738
R135 VSUB.n190 VSUB.n1 88.4738
R136 VSUB.n16 VSUB.n1 88.4738
R137 VSUB.n183 VSUB.n1 88.4738
R138 VSUB.n19 VSUB.n1 88.4738
R139 VSUB.n176 VSUB.n1 88.4738
R140 VSUB.n22 VSUB.n1 88.4738
R141 VSUB.n169 VSUB.n1 88.4738
R142 VSUB.n124 VSUB.n28 76.913
R143 VSUB.n121 VSUB.n29 76.913
R144 VSUB.n117 VSUB.n30 76.913
R145 VSUB.n113 VSUB.n31 76.913
R146 VSUB.n109 VSUB.n32 76.913
R147 VSUB.n105 VSUB.n33 76.913
R148 VSUB.n101 VSUB.n34 76.913
R149 VSUB.n97 VSUB.n35 76.913
R150 VSUB.n93 VSUB.n36 76.913
R151 VSUB.n89 VSUB.n37 76.913
R152 VSUB.n85 VSUB.n38 76.913
R153 VSUB.n81 VSUB.n39 76.913
R154 VSUB.n77 VSUB.n40 76.913
R155 VSUB.n73 VSUB.n41 76.913
R156 VSUB.n129 VSUB.n43 76.913
R157 VSUB.n122 VSUB.n28 76.913
R158 VSUB.n118 VSUB.n29 76.913
R159 VSUB.n114 VSUB.n30 76.913
R160 VSUB.n110 VSUB.n31 76.913
R161 VSUB.n106 VSUB.n32 76.913
R162 VSUB.n102 VSUB.n33 76.913
R163 VSUB.n98 VSUB.n34 76.913
R164 VSUB.n94 VSUB.n35 76.913
R165 VSUB.n90 VSUB.n36 76.913
R166 VSUB.n86 VSUB.n37 76.913
R167 VSUB.n82 VSUB.n38 76.913
R168 VSUB.n78 VSUB.n39 76.913
R169 VSUB.n74 VSUB.n40 76.913
R170 VSUB.n163 VSUB.n131 59.3957
R171 VSUB.n162 VSUB.n161 59.3957
R172 VSUB.n161 VSUB.n132 59.3957
R173 VSUB.t0 VSUB.n155 59.3957
R174 VSUB.n155 VSUB.n154 59.3957
R175 VSUB.n154 VSUB.n139 59.3957
R176 VSUB.n163 VSUB.t6 47.5167
R177 VSUB.n148 VSUB.t8 47.5167
R178 VSUB.n148 VSUB.t13 34.4497
R179 VSUB.t3 VSUB.n132 32.0739
R180 VSUB.n131 VSUB.t1 29.6981
R181 VSUB.t0 VSUB.t3 27.3223
R182 VSUB.t13 VSUB.n147 24.9465
R183 VSUB VSUB.t10 22.6775
R184 VSUB VSUB.n221 21.3368
R185 VSUB.n169 VSUB.n168 17.3554
R186 VSUB.n220 VSUB.n219 16.8426
R187 VSUB.n217 VSUB.n2 16.8426
R188 VSUB.n213 VSUB.n212 16.8426
R189 VSUB.n210 VSUB.n5 16.8426
R190 VSUB.n206 VSUB.n205 16.8426
R191 VSUB.n203 VSUB.n8 16.8426
R192 VSUB.n199 VSUB.n198 16.8426
R193 VSUB.n196 VSUB.n11 16.8426
R194 VSUB.n192 VSUB.n191 16.8426
R195 VSUB.n189 VSUB.n14 16.8426
R196 VSUB.n185 VSUB.n184 16.8426
R197 VSUB.n182 VSUB.n17 16.8426
R198 VSUB.n178 VSUB.n177 16.8426
R199 VSUB.n175 VSUB.n20 16.8426
R200 VSUB.n171 VSUB.n170 16.8426
R201 VSUB.n165 VSUB.n23 16.0005
R202 VSUB.n165 VSUB.n25 16.0005
R203 VSUB.n159 VSUB.n25 16.0005
R204 VSUB.n159 VSUB.n158 16.0005
R205 VSUB.n158 VSUB.n157 16.0005
R206 VSUB.n157 VSUB.n137 16.0005
R207 VSUB.n152 VSUB.n137 16.0005
R208 VSUB.n152 VSUB.n151 16.0005
R209 VSUB.n151 VSUB.n150 16.0005
R210 VSUB.n126 VSUB.n44 15.1819
R211 VSUB.n126 VSUB.n125 15.1819
R212 VSUB.n125 VSUB.n123 15.1819
R213 VSUB.n123 VSUB.n120 15.1819
R214 VSUB.n120 VSUB.n119 15.1819
R215 VSUB.n119 VSUB.n116 15.1819
R216 VSUB.n116 VSUB.n115 15.1819
R217 VSUB.n115 VSUB.n112 15.1819
R218 VSUB.n112 VSUB.n111 15.1819
R219 VSUB.n111 VSUB.n108 15.1819
R220 VSUB.n108 VSUB.n107 15.1819
R221 VSUB.n107 VSUB.n104 15.1819
R222 VSUB.n104 VSUB.n103 15.1819
R223 VSUB.n103 VSUB.n100 15.1819
R224 VSUB.n100 VSUB.n99 15.1819
R225 VSUB.n99 VSUB.n96 15.1819
R226 VSUB.n96 VSUB.n95 15.1819
R227 VSUB.n95 VSUB.n92 15.1819
R228 VSUB.n92 VSUB.n91 15.1819
R229 VSUB.n91 VSUB.n88 15.1819
R230 VSUB.n88 VSUB.n87 15.1819
R231 VSUB.n87 VSUB.n84 15.1819
R232 VSUB.n84 VSUB.n83 15.1819
R233 VSUB.n83 VSUB.n80 15.1819
R234 VSUB.n80 VSUB.n79 15.1819
R235 VSUB.n79 VSUB.n76 15.1819
R236 VSUB.n76 VSUB.n75 15.1819
R237 VSUB.n75 VSUB.n72 15.1819
R238 VSUB.t6 VSUB.n162 11.8796
R239 VSUB.t8 VSUB.n139 11.8796
R240 VSUB.n167 VSUB.n23 9.33175
R241 VSUB.n75 VSUB.n70 9.3005
R242 VSUB.n76 VSUB.n69 9.3005
R243 VSUB.n79 VSUB.n68 9.3005
R244 VSUB.n80 VSUB.n67 9.3005
R245 VSUB.n83 VSUB.n66 9.3005
R246 VSUB.n84 VSUB.n65 9.3005
R247 VSUB.n87 VSUB.n64 9.3005
R248 VSUB.n88 VSUB.n63 9.3005
R249 VSUB.n91 VSUB.n62 9.3005
R250 VSUB.n92 VSUB.n61 9.3005
R251 VSUB.n95 VSUB.n60 9.3005
R252 VSUB.n96 VSUB.n59 9.3005
R253 VSUB.n99 VSUB.n58 9.3005
R254 VSUB.n100 VSUB.n57 9.3005
R255 VSUB.n103 VSUB.n56 9.3005
R256 VSUB.n104 VSUB.n55 9.3005
R257 VSUB.n107 VSUB.n54 9.3005
R258 VSUB.n108 VSUB.n53 9.3005
R259 VSUB.n111 VSUB.n52 9.3005
R260 VSUB.n112 VSUB.n51 9.3005
R261 VSUB.n115 VSUB.n50 9.3005
R262 VSUB.n116 VSUB.n49 9.3005
R263 VSUB.n119 VSUB.n48 9.3005
R264 VSUB.n120 VSUB.n47 9.3005
R265 VSUB.n123 VSUB.n46 9.3005
R266 VSUB.n125 VSUB.n45 9.3005
R267 VSUB.n127 VSUB.n126 9.3005
R268 VSUB.n170 VSUB.n21 9.3005
R269 VSUB.n172 VSUB.n171 9.3005
R270 VSUB.n173 VSUB.n20 9.3005
R271 VSUB.n175 VSUB.n174 9.3005
R272 VSUB.n177 VSUB.n18 9.3005
R273 VSUB.n179 VSUB.n178 9.3005
R274 VSUB.n180 VSUB.n17 9.3005
R275 VSUB.n182 VSUB.n181 9.3005
R276 VSUB.n184 VSUB.n15 9.3005
R277 VSUB.n186 VSUB.n185 9.3005
R278 VSUB.n187 VSUB.n14 9.3005
R279 VSUB.n189 VSUB.n188 9.3005
R280 VSUB.n191 VSUB.n12 9.3005
R281 VSUB.n193 VSUB.n192 9.3005
R282 VSUB.n194 VSUB.n11 9.3005
R283 VSUB.n196 VSUB.n195 9.3005
R284 VSUB.n198 VSUB.n9 9.3005
R285 VSUB.n200 VSUB.n199 9.3005
R286 VSUB.n201 VSUB.n8 9.3005
R287 VSUB.n203 VSUB.n202 9.3005
R288 VSUB.n205 VSUB.n6 9.3005
R289 VSUB.n207 VSUB.n206 9.3005
R290 VSUB.n208 VSUB.n5 9.3005
R291 VSUB.n210 VSUB.n209 9.3005
R292 VSUB.n212 VSUB.n3 9.3005
R293 VSUB.n214 VSUB.n213 9.3005
R294 VSUB.n215 VSUB.n2 9.3005
R295 VSUB.n217 VSUB.n216 9.3005
R296 VSUB.n219 VSUB.n0 9.3005
R297 VSUB.n221 VSUB.n220 9.3005
R298 VSUB.n166 VSUB.n165 9.3005
R299 VSUB.n25 VSUB.n24 9.3005
R300 VSUB.n159 VSUB.n134 9.3005
R301 VSUB.n158 VSUB.n135 9.3005
R302 VSUB.n157 VSUB.n136 9.3005
R303 VSUB.n141 VSUB.n137 9.3005
R304 VSUB.n152 VSUB.n142 9.3005
R305 VSUB.n151 VSUB.n143 9.3005
R306 VSUB.n219 VSUB.n218 8.05542
R307 VSUB.n4 VSUB.n2 8.05542
R308 VSUB.n212 VSUB.n211 8.05542
R309 VSUB.n7 VSUB.n5 8.05542
R310 VSUB.n205 VSUB.n204 8.05542
R311 VSUB.n10 VSUB.n8 8.05542
R312 VSUB.n198 VSUB.n197 8.05542
R313 VSUB.n13 VSUB.n11 8.05542
R314 VSUB.n191 VSUB.n190 8.05542
R315 VSUB.n16 VSUB.n14 8.05542
R316 VSUB.n184 VSUB.n183 8.05542
R317 VSUB.n19 VSUB.n17 8.05542
R318 VSUB.n177 VSUB.n176 8.05542
R319 VSUB.n22 VSUB.n20 8.05542
R320 VSUB.n170 VSUB.n169 8.05542
R321 VSUB.n218 VSUB.n217 8.05542
R322 VSUB.n213 VSUB.n4 8.05542
R323 VSUB.n211 VSUB.n210 8.05542
R324 VSUB.n206 VSUB.n7 8.05542
R325 VSUB.n204 VSUB.n203 8.05542
R326 VSUB.n199 VSUB.n10 8.05542
R327 VSUB.n197 VSUB.n196 8.05542
R328 VSUB.n192 VSUB.n13 8.05542
R329 VSUB.n190 VSUB.n189 8.05542
R330 VSUB.n185 VSUB.n16 8.05542
R331 VSUB.n183 VSUB.n182 8.05542
R332 VSUB.n178 VSUB.n19 8.05542
R333 VSUB.n176 VSUB.n175 8.05542
R334 VSUB.n171 VSUB.n22 8.05542
R335 VSUB.n150 VSUB.n144 4.28224
R336 VSUB.n72 VSUB.n71 4.16217
R337 VSUB.n128 VSUB.n44 4.16217
R338 VSUB.n1 VSUB.t7 3.91925
R339 VSUB.n128 VSUB.n127 2.73899
R340 VSUB.n71 VSUB.n70 2.73899
R341 VSUB.n144 VSUB.n143 2.68753
R342 VSUB.n168 VSUB.n167 0.831914
R343 VSUB.n221 VSUB.n0 0.164974
R344 VSUB.n216 VSUB.n0 0.164974
R345 VSUB.n216 VSUB.n215 0.164974
R346 VSUB.n215 VSUB.n214 0.164974
R347 VSUB.n214 VSUB.n3 0.164974
R348 VSUB.n209 VSUB.n3 0.164974
R349 VSUB.n209 VSUB.n208 0.164974
R350 VSUB.n208 VSUB.n207 0.164974
R351 VSUB.n207 VSUB.n6 0.164974
R352 VSUB.n202 VSUB.n6 0.164974
R353 VSUB.n202 VSUB.n201 0.164974
R354 VSUB.n201 VSUB.n200 0.164974
R355 VSUB.n200 VSUB.n9 0.164974
R356 VSUB.n195 VSUB.n9 0.164974
R357 VSUB.n195 VSUB.n194 0.164974
R358 VSUB.n194 VSUB.n193 0.164974
R359 VSUB.n193 VSUB.n12 0.164974
R360 VSUB.n188 VSUB.n12 0.164974
R361 VSUB.n188 VSUB.n187 0.164974
R362 VSUB.n187 VSUB.n186 0.164974
R363 VSUB.n186 VSUB.n15 0.164974
R364 VSUB.n181 VSUB.n15 0.164974
R365 VSUB.n181 VSUB.n180 0.164974
R366 VSUB.n180 VSUB.n179 0.164974
R367 VSUB.n179 VSUB.n18 0.164974
R368 VSUB.n174 VSUB.n18 0.164974
R369 VSUB.n174 VSUB.n173 0.164974
R370 VSUB.n173 VSUB.n172 0.164974
R371 VSUB.n172 VSUB.n21 0.164974
R372 VSUB.n168 VSUB.n21 0.164974
R373 VSUB.n166 VSUB.n24 0.15675
R374 VSUB.n134 VSUB.n24 0.15675
R375 VSUB.n135 VSUB.n134 0.15675
R376 VSUB.n136 VSUB.n135 0.15675
R377 VSUB.n141 VSUB.n136 0.15675
R378 VSUB.n142 VSUB.n141 0.15675
R379 VSUB.n143 VSUB.n142 0.15675
R380 VSUB.n127 VSUB.n45 0.148756
R381 VSUB.n46 VSUB.n45 0.148756
R382 VSUB.n47 VSUB.n46 0.148756
R383 VSUB.n48 VSUB.n47 0.148756
R384 VSUB.n49 VSUB.n48 0.148756
R385 VSUB.n50 VSUB.n49 0.148756
R386 VSUB.n51 VSUB.n50 0.148756
R387 VSUB.n52 VSUB.n51 0.148756
R388 VSUB.n53 VSUB.n52 0.148756
R389 VSUB.n54 VSUB.n53 0.148756
R390 VSUB.n55 VSUB.n54 0.148756
R391 VSUB.n56 VSUB.n55 0.148756
R392 VSUB.n57 VSUB.n56 0.148756
R393 VSUB.n58 VSUB.n57 0.148756
R394 VSUB.n59 VSUB.n58 0.148756
R395 VSUB.n60 VSUB.n59 0.148756
R396 VSUB.n61 VSUB.n60 0.148756
R397 VSUB.n62 VSUB.n61 0.148756
R398 VSUB.n63 VSUB.n62 0.148756
R399 VSUB.n64 VSUB.n63 0.148756
R400 VSUB.n65 VSUB.n64 0.148756
R401 VSUB.n66 VSUB.n65 0.148756
R402 VSUB.n67 VSUB.n66 0.148756
R403 VSUB.n68 VSUB.n67 0.148756
R404 VSUB.n69 VSUB.n68 0.148756
R405 VSUB.n70 VSUB.n69 0.148756
R406 VSUB.n167 VSUB.n166 0.1255
C0 n1 n3 0.18432f
C1 n1 t1 0.04214f
C2 n3 n2 1.78771f
C3 n3 t2 0.67083f
C4 t1 n2 0.61878f
C5 t1 t2 0.20046f
C6 t1 t0 0.20272f
C7 n1 n2 2.13102f
C8 n1 t2 0.10844f
C9 n1 t0 0.60842f
C10 n3 t1 0.62875f
C11 n2 t0 0.5787f
C12 t2 VSUB 1.18406f
C13 t1 VSUB 0.42794f
C14 t0 VSUB 0.47752f
C15 n3 VSUB 5.16376f
C16 n2 VSUB 3.50506f
C17 n1 VSUB 4.69585f
C18 ne2 VSUB 0.70286f
C19 a_297_1550.t1 VSUB 0.25541f
C20 a_297_1550.t0 VSUB 0.25541f
C21 ne2.t0 VSUB 0.05596f
C22 a_801_1550.t1 VSUB 0.36749f
C23 a_801_1550.t0 VSUB 0.36749f
C24 n1.t1 VSUB 0.07657f
C25 n1.t0 VSUB 0.11124f
C26 n1.n0 VSUB 0.58062f
C27 n1.t2 VSUB 1.59133f
C28 n2.t2 VSUB 0.17599f
C29 n2.t1 VSUB 0.12114f
C30 n2.n0 VSUB 0.89146f
C31 n2.t0 VSUB 0.54032f
C32 n2.t3 VSUB 0.54032f
C33 n2.n1 VSUB 2.02804f
C34 a_2313_1550.t1 VSUB 0.36363f
C35 a_2313_1550.t0 VSUB 0.36363f
C36 n3.t3 VSUB 0.0857f
C37 n3.t1 VSUB 0.1245f
C38 n3.n0 VSUB 0.63961f
C39 n3.t2 VSUB 0.38223f
C40 n3.t0 VSUB 0.38223f
C41 n3.n1 VSUB 1.45809f
C42 a_3321_1550.t1 VSUB 0.36205f
C43 a_3321_1550.t0 VSUB 0.36205f
C44 a_3825_1550.t1 VSUB 0.36204f
C45 a_3825_1550.t0 VSUB 0.36204f
C46 a_4329_1550.t1 VSUB 0.18102f
C47 a_4329_1550.t0 VSUB 0.18102f
.ends
