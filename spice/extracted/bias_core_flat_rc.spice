* NGSPICE file created from ptatcore.ext - technology: sky130A

.subckt ptatcore
X0 a_1325_8758.t1 a_1805_7248.t1 VSUB.t15 sky130_fd_pr__res_high_po_0p35 l=5.47
X1 a_1325_6458.t1 nd12.t3 VSUB.t15 sky130_fd_pr__res_high_po_0p35 l=5.47
X2 a_6605_6458.t0 a_7085_4948.t0 VSUB.t3 sky130_fd_pr__res_high_po_0p35 l=5.47
X3 a_1325_4158.t0 a_1805_2648.t0 VSUB.t15 sky130_fd_pr__res_high_po_0p35 l=5.47
X4 a_6125_4158.t1 a_6605_2648.t1 VSUB.t4 sky130_fd_pr__res_high_po_0p35 l=5.47
X5 a_7085_4158.t0 a_6605_2648.t0 VSUB.t3 sky130_fd_pr__res_high_po_0p35 l=5.47
X6 nsl1.t2 nsl2.t1 nsl2.t2 vdd.t5 sky130_fd_pr__pfet_g5v0d10v5 ad=2.4 pd=9.2 as=2.4 ps=9.2 w=4 l=8
X7 a_6605_6458.t1 a_6125_4948.t0 VSUB.t4 sky130_fd_pr__res_high_po_0p35 l=5.47
X8 a_3245_8758.t1 a_2765_7248.t1 VSUB.t16 sky130_fd_pr__res_high_po_0p35 l=5.47
X9 a_3245_6458.t1 a_2765_4948.t1 VSUB.t16 sky130_fd_pr__res_high_po_0p35 l=5.47
X10 a_3245_4158.t0 a_2765_2648.t1 VSUB.t16 sky130_fd_pr__res_high_po_0p35 l=5.47
X11 a_5165_1858.t1 a_4685_348.t1 VSUB.t11 sky130_fd_pr__res_high_po_0p35 l=5.47
X12 a_5165_1858.t0 a_5645_348.t1 VSUB.t8 sky130_fd_pr__res_high_po_0p35 l=5.47
X13 a_7565_6458.t1 nd055.t1 VSUB.t17 sky130_fd_pr__res_high_po_0p35 l=5.47
X14 a_8045_4158.t1 a_7565_2648.t0 VSUB.t17 sky130_fd_pr__res_high_po_0p35 l=5.47
X15 a_8045_1858.t0 a_7565_348.t0 VSUB.t17 sky130_fd_pr__res_high_po_0p35 l=5.47
X16 a_4205_4158.t0 a_3725_2648.t0 VSUB.t1 sky130_fd_pr__res_high_po_0p35 l=5.47
X17 a_8045_1858.t1 a_8525_348.t1 VSUB.t6 sky130_fd_pr__res_high_po_0p35 l=5.47
X18 VSUB.t5 a_3725_7248.t1 VSUB.t1 sky130_fd_pr__res_high_po_0p35 l=5.47
X19 a_4205_6458.t0 a_3725_4948.t0 VSUB.t1 sky130_fd_pr__res_high_po_0p35 l=5.47
X20 a_365_4948.t1 a_8525_2648.t0 VSUB.t12 sky130_fd_pr__res_high_po_0p35 l=5.47
X21 pbias nsl1.t0 nsl1.t1 vdd.t3 sky130_fd_pr__pfet_g5v0d10v5 ad=2.4 pd=9.2 as=2.4 ps=9.2 w=4 l=8
X22 a_8525_6458.t1 a_365_7248.t1 VSUB.t12 sky130_fd_pr__res_high_po_0p35 l=5.47
X23 a_365_8758.t1 a_845_7248.t0 VSUB.t13 sky130_fd_pr__res_high_po_0p35 l=5.47
X24 a_365_6458.t1 a_845_4948.t1 VSUB.t13 sky130_fd_pr__res_high_po_0p35 l=5.47
X25 a_365_4158.t0 a_845_2648.t0 VSUB.t13 sky130_fd_pr__res_high_po_0p35 l=5.47
X26 a_4205_1858.t1 a_4685_348.t0 VSUB.t20 sky130_fd_pr__res_high_po_0p35 l=5.47
X27 a_365_1858.t0 vdd.t2 VSUB.t7 sky130_fd_pr__res_high_po_0p35 l=5.47
X28 a_2285_8758.t1 a_2765_7248.t0 VSUB.t9 sky130_fd_pr__res_high_po_0p35 l=5.47
X29 a_2285_6458.t1 a_2765_4948.t0 VSUB.t9 sky130_fd_pr__res_high_po_0p35 l=5.47
X30 a_2285_4158.t0 a_2765_2648.t0 VSUB.t9 sky130_fd_pr__res_high_po_0p35 l=5.47
X31 a_365_1858.t1 a_845_348.t0 VSUB.t13 sky130_fd_pr__res_high_po_0p35 l=5.47
X32 a_7085_1858.t1 a_6605_348.t1 VSUB.t3 sky130_fd_pr__res_high_po_0p35 l=5.47
X33 a_7565_6458.t0 a_7085_4948.t1 VSUB.t14 sky130_fd_pr__res_high_po_0p35 l=5.47
X34 a_7085_4158.t1 a_7565_2648.t1 VSUB.t14 sky130_fd_pr__res_high_po_0p35 l=5.47
X35 a_7085_1858.t0 a_7565_348.t1 VSUB.t14 sky130_fd_pr__res_high_po_0p35 l=5.47
X36 vdd.t9 pbias pbias vdd.t8 sky130_fd_pr__pfet_g5v0d10v5 ad=9.6 pd=33.2 as=9.6 ps=33.2 w=16 l=8
X37 a_3245_6458.t0 a_3725_4948.t1 VSUB.t0 sky130_fd_pr__res_high_po_0p35 l=5.47
X38 a_3245_4158.t1 a_3725_2648.t1 VSUB.t0 sky130_fd_pr__res_high_po_0p35 l=5.47
X39 a_1325_1858.t1 a_845_348.t1 VSUB.t10 sky130_fd_pr__res_high_po_0p35 l=5.47
X40 a_3245_8758.t0 a_3725_7248.t0 VSUB.t0 sky130_fd_pr__res_high_po_0p35 l=5.47
X41 a_8525_6458.t0 nd055.t0 VSUB.t6 sky130_fd_pr__res_high_po_0p35 l=5.47
X42 a_8045_4158.t0 a_8525_2648.t1 VSUB.t6 sky130_fd_pr__res_high_po_0p35 l=5.47
X43 a_1325_1858.t0 a_1805_348.t1 VSUB.t15 sky130_fd_pr__res_high_po_0p35 l=5.47
X44 nb.t0 nb VSUB.t18 VSUB sky130_fd_pr__npn_05v5_W1p00L1p00
**devattr s=40000,800 d=2446096,6256
X45 nb vdd.t1 sky130_fd_pr__cap_mim_m3_1 l=22.36 w=22.36
X46 vcasc.t0 a_4685_4948.t0 VSUB.t11 sky130_fd_pr__res_high_po_0p35 l=5.47
X47 a_5165_4158.t1 a_4685_2648.t1 VSUB.t11 sky130_fd_pr__res_high_po_0p35 l=5.47
X48 a_4205_1858.t0 a_3725_348.t0 VSUB.t1 sky130_fd_pr__res_high_po_0p35 l=5.47
X49 nsl3.t0 nd12.t1 nd12.t2 vdd.t0 sky130_fd_pr__pfet_g5v0d10v5 ad=2.4 pd=9.2 as=2.4 ps=9.2 w=4 l=8
X50 pbias nb ne2.t2 VSUB sky130_fd_pr__npn_05v5_W1p00L2p00
**devattr s=80000,1200 d=2758896,6656
X51 pbias.t3 nb ne2.t0 VSUB sky130_fd_pr__npn_05v5_W1p00L2p00
**devattr s=80000,1200 d=2758896,6656
X52 pbias nb ne2.t3 VSUB sky130_fd_pr__npn_05v5_W1p00L2p00
**devattr s=80000,1200 d=2758896,6656
X53 a_1325_8758.t0 a_845_7248.t1 VSUB.t10 sky130_fd_pr__res_high_po_0p35 l=5.47
X54 a_1325_6458.t0 a_845_4948.t0 VSUB.t10 sky130_fd_pr__res_high_po_0p35 l=5.47
X55 a_1325_4158.t1 a_845_2648.t1 VSUB.t10 sky130_fd_pr__res_high_po_0p35 l=5.47
X56 a_5645_6458.t1 a_6125_4948.t1 VSUB.t19 sky130_fd_pr__res_high_po_0p35 l=5.47
X57 a_6125_4158.t0 a_5645_2648.t1 VSUB.t19 sky130_fd_pr__res_high_po_0p35 l=5.47
X58 a_3245_1858.t1 a_2765_348.t1 VSUB.t16 sky130_fd_pr__res_high_po_0p35 l=5.47
X59 a_3245_1858.t0 a_3725_348.t1 VSUB.t0 sky130_fd_pr__res_high_po_0p35 l=5.47
X60 a_4205_6458.t1 a_4685_4948.t1 VSUB.t20 sky130_fd_pr__res_high_po_0p35 l=5.47
X61 a_4205_4158.t1 a_4685_2648.t0 VSUB.t20 sky130_fd_pr__res_high_po_0p35 l=5.47
X62 a_6125_1858.t0 a_5645_348.t0 VSUB.t19 sky130_fd_pr__res_high_po_0p35 l=5.47
X63 nsl2.t0 nsl3.t1 nsl3.t2 vdd.t4 sky130_fd_pr__pfet_g5v0d10v5 ad=2.4 pd=9.2 as=2.4 ps=9.2 w=4 l=8
X64 a_6125_1858.t1 a_6605_348.t0 VSUB.t4 sky130_fd_pr__res_high_po_0p35 l=5.47
X65 a_365_8758.t0 a_365_7248.t0 VSUB.t7 sky130_fd_pr__res_high_po_0p35 l=5.47
X66 a_365_6458.t0 a_365_4948.t0 VSUB.t7 sky130_fd_pr__res_high_po_0p35 l=5.47
X67 a_365_4158.t1 a_365_2648.t1 VSUB.t7 sky130_fd_pr__res_high_po_0p35 l=5.47
X68 pbias nb ne2.t1 VSUB sky130_fd_pr__npn_05v5_W1p00L2p00
**devattr s=80000,1200 d=2758896,6656
X69 a_5645_6458.t0 vcasc.t1 VSUB.t8 sky130_fd_pr__res_high_po_0p35 l=5.47
X70 a_5165_4158.t0 a_5645_2648.t0 VSUB.t8 sky130_fd_pr__res_high_po_0p35 l=5.47
X71 a_365_2648.t0 a_8525_348.t0 VSUB.t12 sky130_fd_pr__res_high_po_0p35 l=5.47
X72 a_2285_8758.t0 a_1805_7248.t0 VSUB.t2 sky130_fd_pr__res_high_po_0p35 l=5.47
X73 a_2285_6458.t0 nd12.t0 VSUB.t2 sky130_fd_pr__res_high_po_0p35 l=5.47
X74 a_2285_4158.t1 a_1805_2648.t1 VSUB.t2 sky130_fd_pr__res_high_po_0p35 l=5.47
X75 a_2285_1858.t0 a_1805_348.t0 VSUB.t2 sky130_fd_pr__res_high_po_0p35 l=5.47
X76 a_2285_1858.t1 a_2765_348.t0 VSUB.t9 sky130_fd_pr__res_high_po_0p35 l=5.47
X77 vdd.t7 pbias nb vdd.t6 sky130_fd_pr__pfet_g5v0d10v5 ad=9.6 pd=33.2 as=9.6 ps=33.2 w=16 l=8
R0 VSUB.n909 VSUB.n455 37600
R1 VSUB.n453 VSUB.n226 16013.2
R2 VSUB.n454 VSUB.n403 15501.9
R3 VSUB.n453 VSUB.n452 9725.25
R4 VSUB.n226 VSUB.n154 7877.84
R5 VSUB.n1198 VSUB.n154 7324.55
R6 VSUB.n454 VSUB.n453 6309.65
R7 VSUB.n452 VSUB.n118 4531.79
R8 VSUB.n1135 VSUB.n226 4362.55
R9 VSUB.n455 VSUB.n454 2696.71
R10 VSUB.n452 VSUB.n154 2455.02
R11 VSUB.n860 VSUB.n455 2188.05
R12 VSUB.n1172 VSUB.n153 733.333
R13 VSUB.n1172 VSUB.n1171 733.333
R14 VSUB.n1171 VSUB.n1170 733.333
R15 VSUB.n1170 VSUB.n179 733.333
R16 VSUB.n205 VSUB.n179 733.333
R17 VSUB.n206 VSUB.n205 733.333
R18 VSUB.n207 VSUB.n206 733.333
R19 VSUB.n209 VSUB.n207 733.333
R20 VSUB.n210 VSUB.n209 733.333
R21 VSUB.n211 VSUB.n210 733.333
R22 VSUB.n212 VSUB.n211 733.333
R23 VSUB.n214 VSUB.n212 733.333
R24 VSUB.n215 VSUB.n214 733.333
R25 VSUB.n216 VSUB.n215 733.333
R26 VSUB.n217 VSUB.n216 733.333
R27 VSUB.n218 VSUB.n217 733.333
R28 VSUB.n1231 VSUB.n1230 733.333
R29 VSUB.n1230 VSUB.n1229 733.333
R30 VSUB.n1229 VSUB.n119 733.333
R31 VSUB.n1223 VSUB.n119 733.333
R32 VSUB.n1223 VSUB.n1222 733.333
R33 VSUB.n1222 VSUB.n1221 733.333
R34 VSUB.n1221 VSUB.n129 733.333
R35 VSUB.n1215 VSUB.n129 733.333
R36 VSUB.n1215 VSUB.n1214 733.333
R37 VSUB.n1214 VSUB.n1213 733.333
R38 VSUB.n1213 VSUB.n137 733.333
R39 VSUB.n1207 VSUB.n137 733.333
R40 VSUB.n1207 VSUB.n1206 733.333
R41 VSUB.n1206 VSUB.n1205 733.333
R42 VSUB.n1205 VSUB.n145 733.333
R43 VSUB.n1199 VSUB.n145 733.333
R44 VSUB.n1198 VSUB.n1197 724.552
R45 VSUB.n1231 VSUB.n118 689.333
R46 VSUB.n1144 VSUB.n218 679.47
R47 VSUB.n107 VSUB.n106 589.327
R48 VSUB.n682 VSUB.n681 589.327
R49 VSUB.n203 VSUB.n200 585
R50 VSUB.n218 VSUB.n203 585
R51 VSUB.n1150 VSUB.n199 585
R52 VSUB.n217 VSUB.n199 585
R53 VSUB.n1151 VSUB.n198 585
R54 VSUB.n216 VSUB.n198 585
R55 VSUB.n1152 VSUB.n197 585
R56 VSUB.n215 VSUB.n197 585
R57 VSUB.n213 VSUB.n195 585
R58 VSUB.n214 VSUB.n213 585
R59 VSUB.n1156 VSUB.n194 585
R60 VSUB.n212 VSUB.n194 585
R61 VSUB.n1157 VSUB.n193 585
R62 VSUB.n211 VSUB.n193 585
R63 VSUB.n1158 VSUB.n192 585
R64 VSUB.n210 VSUB.n192 585
R65 VSUB.n208 VSUB.n190 585
R66 VSUB.n209 VSUB.n208 585
R67 VSUB.n1162 VSUB.n189 585
R68 VSUB.n207 VSUB.n189 585
R69 VSUB.n1163 VSUB.n188 585
R70 VSUB.n206 VSUB.n188 585
R71 VSUB.n1164 VSUB.n187 585
R72 VSUB.n205 VSUB.n187 585
R73 VSUB.n182 VSUB.n180 585
R74 VSUB.n180 VSUB.n179 585
R75 VSUB.n1169 VSUB.n1168 585
R76 VSUB.n1170 VSUB.n1169 585
R77 VSUB.n181 VSUB.n177 585
R78 VSUB.n1171 VSUB.n177 585
R79 VSUB.n1173 VSUB.n178 585
R80 VSUB.n1173 VSUB.n1172 585
R81 VSUB.n1174 VSUB.n176 585
R82 VSUB.n1174 VSUB.n153 585
R83 VSUB.n1201 VSUB.n1200 585
R84 VSUB.n1200 VSUB.n1199 585
R85 VSUB.n1202 VSUB.n146 585
R86 VSUB.n146 VSUB.n145 585
R87 VSUB.n1204 VSUB.n1203 585
R88 VSUB.n1205 VSUB.n1204 585
R89 VSUB.n144 VSUB.n143 585
R90 VSUB.n1206 VSUB.n144 585
R91 VSUB.n1209 VSUB.n1208 585
R92 VSUB.n1208 VSUB.n1207 585
R93 VSUB.n1210 VSUB.n138 585
R94 VSUB.n138 VSUB.n137 585
R95 VSUB.n1212 VSUB.n1211 585
R96 VSUB.n1213 VSUB.n1212 585
R97 VSUB.n136 VSUB.n135 585
R98 VSUB.n1214 VSUB.n136 585
R99 VSUB.n1217 VSUB.n1216 585
R100 VSUB.n1216 VSUB.n1215 585
R101 VSUB.n1218 VSUB.n130 585
R102 VSUB.n130 VSUB.n129 585
R103 VSUB.n1220 VSUB.n1219 585
R104 VSUB.n1221 VSUB.n1220 585
R105 VSUB.n128 VSUB.n127 585
R106 VSUB.n1222 VSUB.n128 585
R107 VSUB.n1225 VSUB.n1224 585
R108 VSUB.n1224 VSUB.n1223 585
R109 VSUB.n1226 VSUB.n120 585
R110 VSUB.n120 VSUB.n119 585
R111 VSUB.n1228 VSUB.n1227 585
R112 VSUB.n1229 VSUB.n1228 585
R113 VSUB.n121 VSUB.n117 585
R114 VSUB.n1230 VSUB.n117 585
R115 VSUB.n1232 VSUB.n115 585
R116 VSUB.n1232 VSUB.n1231 585
R117 VSUB.n1234 VSUB.n1233 585
R118 VSUB.n1235 VSUB.n110 585
R119 VSUB.n1237 VSUB.n1236 585
R120 VSUB.n1239 VSUB.n109 585
R121 VSUB.n1240 VSUB.n3 585
R122 VSUB.n1243 VSUB.n1242 585
R123 VSUB.n4 VSUB.n2 585
R124 VSUB.n50 VSUB.n49 585
R125 VSUB.n52 VSUB.n51 585
R126 VSUB.n54 VSUB.n53 585
R127 VSUB.n56 VSUB.n55 585
R128 VSUB.n58 VSUB.n57 585
R129 VSUB.n60 VSUB.n59 585
R130 VSUB.n62 VSUB.n61 585
R131 VSUB.n64 VSUB.n63 585
R132 VSUB.n66 VSUB.n65 585
R133 VSUB.n68 VSUB.n67 585
R134 VSUB.n70 VSUB.n69 585
R135 VSUB.n72 VSUB.n71 585
R136 VSUB.n74 VSUB.n73 585
R137 VSUB.n76 VSUB.n75 585
R138 VSUB.n78 VSUB.n77 585
R139 VSUB.n80 VSUB.n79 585
R140 VSUB.n82 VSUB.n81 585
R141 VSUB.n84 VSUB.n83 585
R142 VSUB.n86 VSUB.n85 585
R143 VSUB.n88 VSUB.n87 585
R144 VSUB.n90 VSUB.n89 585
R145 VSUB.n92 VSUB.n91 585
R146 VSUB.n94 VSUB.n93 585
R147 VSUB.n96 VSUB.n95 585
R148 VSUB.n98 VSUB.n97 585
R149 VSUB.n100 VSUB.n99 585
R150 VSUB.n102 VSUB.n101 585
R151 VSUB.n104 VSUB.n103 585
R152 VSUB.n21 VSUB.n20 585
R153 VSUB.n108 VSUB.n107 585
R154 VSUB.n1176 VSUB.n1175 585
R155 VSUB.n1178 VSUB.n1177 585
R156 VSUB.n1180 VSUB.n1179 585
R157 VSUB.n1182 VSUB.n1181 585
R158 VSUB.n1184 VSUB.n1183 585
R159 VSUB.n1186 VSUB.n1185 585
R160 VSUB.n1188 VSUB.n1187 585
R161 VSUB.n1190 VSUB.n1189 585
R162 VSUB.n1192 VSUB.n1191 585
R163 VSUB.n1193 VSUB.n161 585
R164 VSUB.n1195 VSUB.n1194 585
R165 VSUB.n162 VSUB.n160 585
R166 VSUB.n152 VSUB.n151 585
R167 VSUB.n1197 VSUB.n152 585
R168 VSUB.n402 VSUB.n401 585
R169 VSUB.n958 VSUB.n402 585
R170 VSUB.n961 VSUB.n960 585
R171 VSUB.n960 VSUB.n959 585
R172 VSUB.n962 VSUB.n396 585
R173 VSUB.n396 VSUB.n395 585
R174 VSUB.n964 VSUB.n963 585
R175 VSUB.n965 VSUB.n964 585
R176 VSUB.n394 VSUB.n393 585
R177 VSUB.n966 VSUB.n394 585
R178 VSUB.n969 VSUB.n968 585
R179 VSUB.n968 VSUB.n967 585
R180 VSUB.n970 VSUB.n388 585
R181 VSUB.n388 VSUB.n387 585
R182 VSUB.n972 VSUB.n971 585
R183 VSUB.n973 VSUB.n972 585
R184 VSUB.n386 VSUB.n385 585
R185 VSUB.n974 VSUB.n386 585
R186 VSUB.n977 VSUB.n976 585
R187 VSUB.n976 VSUB.n975 585
R188 VSUB.n978 VSUB.n380 585
R189 VSUB.n380 VSUB.n379 585
R190 VSUB.n980 VSUB.n979 585
R191 VSUB.n981 VSUB.n980 585
R192 VSUB.n378 VSUB.n377 585
R193 VSUB.n982 VSUB.n378 585
R194 VSUB.n985 VSUB.n984 585
R195 VSUB.n984 VSUB.n983 585
R196 VSUB.n986 VSUB.n372 585
R197 VSUB.n372 VSUB.n371 585
R198 VSUB.n988 VSUB.n987 585
R199 VSUB.n989 VSUB.n988 585
R200 VSUB.n370 VSUB.n369 585
R201 VSUB.n990 VSUB.n370 585
R202 VSUB.n993 VSUB.n992 585
R203 VSUB.n992 VSUB.n991 585
R204 VSUB.n994 VSUB.n364 585
R205 VSUB.n364 VSUB.n363 585
R206 VSUB.n996 VSUB.n995 585
R207 VSUB.n997 VSUB.n996 585
R208 VSUB.n362 VSUB.n361 585
R209 VSUB.n998 VSUB.n362 585
R210 VSUB.n1001 VSUB.n1000 585
R211 VSUB.n1000 VSUB.n999 585
R212 VSUB.n1002 VSUB.n356 585
R213 VSUB.n356 VSUB.n355 585
R214 VSUB.n1004 VSUB.n1003 585
R215 VSUB.n1005 VSUB.n1004 585
R216 VSUB.n354 VSUB.n353 585
R217 VSUB.n1006 VSUB.n354 585
R218 VSUB.n1009 VSUB.n1008 585
R219 VSUB.n1008 VSUB.n1007 585
R220 VSUB.n1010 VSUB.n348 585
R221 VSUB.n348 VSUB.n347 585
R222 VSUB.n1012 VSUB.n1011 585
R223 VSUB.n1013 VSUB.n1012 585
R224 VSUB.n346 VSUB.n345 585
R225 VSUB.n1014 VSUB.n346 585
R226 VSUB.n1017 VSUB.n1016 585
R227 VSUB.n1016 VSUB.n1015 585
R228 VSUB.n1018 VSUB.n340 585
R229 VSUB.n340 VSUB.n339 585
R230 VSUB.n1020 VSUB.n1019 585
R231 VSUB.n1021 VSUB.n1020 585
R232 VSUB.n338 VSUB.n337 585
R233 VSUB.n1022 VSUB.n338 585
R234 VSUB.n1025 VSUB.n1024 585
R235 VSUB.n1024 VSUB.n1023 585
R236 VSUB.n1026 VSUB.n332 585
R237 VSUB.n332 VSUB.n331 585
R238 VSUB.n1028 VSUB.n1027 585
R239 VSUB.n1029 VSUB.n1028 585
R240 VSUB.n330 VSUB.n329 585
R241 VSUB.n1030 VSUB.n330 585
R242 VSUB.n1033 VSUB.n1032 585
R243 VSUB.n1032 VSUB.n1031 585
R244 VSUB.n1034 VSUB.n324 585
R245 VSUB.n324 VSUB.n323 585
R246 VSUB.n1036 VSUB.n1035 585
R247 VSUB.n1037 VSUB.n1036 585
R248 VSUB.n322 VSUB.n321 585
R249 VSUB.n1038 VSUB.n322 585
R250 VSUB.n1041 VSUB.n1040 585
R251 VSUB.n1040 VSUB.n1039 585
R252 VSUB.n1042 VSUB.n316 585
R253 VSUB.n316 VSUB.n315 585
R254 VSUB.n1044 VSUB.n1043 585
R255 VSUB.n1045 VSUB.n1044 585
R256 VSUB.n314 VSUB.n313 585
R257 VSUB.n1046 VSUB.n314 585
R258 VSUB.n1049 VSUB.n1048 585
R259 VSUB.n1048 VSUB.n1047 585
R260 VSUB.n1050 VSUB.n308 585
R261 VSUB.n308 VSUB.n307 585
R262 VSUB.n1052 VSUB.n1051 585
R263 VSUB.n1053 VSUB.n1052 585
R264 VSUB.n306 VSUB.n305 585
R265 VSUB.n1054 VSUB.n306 585
R266 VSUB.n1057 VSUB.n1056 585
R267 VSUB.n1056 VSUB.n1055 585
R268 VSUB.n1058 VSUB.n300 585
R269 VSUB.n300 VSUB.n299 585
R270 VSUB.n1060 VSUB.n1059 585
R271 VSUB.n1061 VSUB.n1060 585
R272 VSUB.n298 VSUB.n297 585
R273 VSUB.n1062 VSUB.n298 585
R274 VSUB.n1065 VSUB.n1064 585
R275 VSUB.n1064 VSUB.n1063 585
R276 VSUB.n1066 VSUB.n292 585
R277 VSUB.n292 VSUB.n291 585
R278 VSUB.n1068 VSUB.n1067 585
R279 VSUB.n1069 VSUB.n1068 585
R280 VSUB.n290 VSUB.n289 585
R281 VSUB.n1070 VSUB.n290 585
R282 VSUB.n1073 VSUB.n1072 585
R283 VSUB.n1072 VSUB.n1071 585
R284 VSUB.n1074 VSUB.n284 585
R285 VSUB.n284 VSUB.n283 585
R286 VSUB.n1076 VSUB.n1075 585
R287 VSUB.n1077 VSUB.n1076 585
R288 VSUB.n282 VSUB.n281 585
R289 VSUB.n1078 VSUB.n282 585
R290 VSUB.n1081 VSUB.n1080 585
R291 VSUB.n1080 VSUB.n1079 585
R292 VSUB.n1082 VSUB.n276 585
R293 VSUB.n276 VSUB.n275 585
R294 VSUB.n1084 VSUB.n1083 585
R295 VSUB.n1085 VSUB.n1084 585
R296 VSUB.n274 VSUB.n273 585
R297 VSUB.n1086 VSUB.n274 585
R298 VSUB.n1089 VSUB.n1088 585
R299 VSUB.n1088 VSUB.n1087 585
R300 VSUB.n1090 VSUB.n268 585
R301 VSUB.n268 VSUB.n267 585
R302 VSUB.n1092 VSUB.n1091 585
R303 VSUB.n1093 VSUB.n1092 585
R304 VSUB.n266 VSUB.n265 585
R305 VSUB.n1094 VSUB.n266 585
R306 VSUB.n1097 VSUB.n1096 585
R307 VSUB.n1096 VSUB.n1095 585
R308 VSUB.n1098 VSUB.n260 585
R309 VSUB.n260 VSUB.n259 585
R310 VSUB.n1100 VSUB.n1099 585
R311 VSUB.n1101 VSUB.n1100 585
R312 VSUB.n258 VSUB.n257 585
R313 VSUB.n1102 VSUB.n258 585
R314 VSUB.n1105 VSUB.n1104 585
R315 VSUB.n1104 VSUB.n1103 585
R316 VSUB.n1106 VSUB.n252 585
R317 VSUB.n252 VSUB.n251 585
R318 VSUB.n1108 VSUB.n1107 585
R319 VSUB.n1109 VSUB.n1108 585
R320 VSUB.n250 VSUB.n249 585
R321 VSUB.n1110 VSUB.n250 585
R322 VSUB.n1113 VSUB.n1112 585
R323 VSUB.n1112 VSUB.n1111 585
R324 VSUB.n1114 VSUB.n244 585
R325 VSUB.n244 VSUB.n243 585
R326 VSUB.n1116 VSUB.n1115 585
R327 VSUB.n1117 VSUB.n1116 585
R328 VSUB.n242 VSUB.n241 585
R329 VSUB.n1118 VSUB.n242 585
R330 VSUB.n1121 VSUB.n1120 585
R331 VSUB.n1120 VSUB.n1119 585
R332 VSUB.n1122 VSUB.n236 585
R333 VSUB.n236 VSUB.n235 585
R334 VSUB.n1124 VSUB.n1123 585
R335 VSUB.n1125 VSUB.n1124 585
R336 VSUB.n234 VSUB.n233 585
R337 VSUB.n1126 VSUB.n234 585
R338 VSUB.n1129 VSUB.n1128 585
R339 VSUB.n1128 VSUB.n1127 585
R340 VSUB.n1130 VSUB.n228 585
R341 VSUB.n228 VSUB.n227 585
R342 VSUB.n1132 VSUB.n1131 585
R343 VSUB.n1133 VSUB.n1132 585
R344 VSUB.n225 VSUB.n224 585
R345 VSUB.n1134 VSUB.n225 585
R346 VSUB.n1138 VSUB.n1137 585
R347 VSUB.n1137 VSUB.n1136 585
R348 VSUB.n1139 VSUB.n220 585
R349 VSUB.n220 VSUB.n219 585
R350 VSUB.n1141 VSUB.n1140 585
R351 VSUB.n1142 VSUB.n1141 585
R352 VSUB.n204 VSUB.n202 585
R353 VSUB.n1143 VSUB.n204 585
R354 VSUB.n1146 VSUB.n1145 585
R355 VSUB.n1145 VSUB.n1144 585
R356 VSUB.n503 VSUB.n502 585
R357 VSUB.n861 VSUB.n503 585
R358 VSUB.n864 VSUB.n863 585
R359 VSUB.n863 VSUB.n862 585
R360 VSUB.n865 VSUB.n497 585
R361 VSUB.n497 VSUB.n496 585
R362 VSUB.n867 VSUB.n866 585
R363 VSUB.n868 VSUB.n867 585
R364 VSUB.n495 VSUB.n494 585
R365 VSUB.n869 VSUB.n495 585
R366 VSUB.n872 VSUB.n871 585
R367 VSUB.n871 VSUB.n870 585
R368 VSUB.n873 VSUB.n489 585
R369 VSUB.n489 VSUB.n488 585
R370 VSUB.n875 VSUB.n874 585
R371 VSUB.n876 VSUB.n875 585
R372 VSUB.n487 VSUB.n486 585
R373 VSUB.n877 VSUB.n487 585
R374 VSUB.n880 VSUB.n879 585
R375 VSUB.n879 VSUB.n878 585
R376 VSUB.n881 VSUB.n481 585
R377 VSUB.n481 VSUB.n480 585
R378 VSUB.n883 VSUB.n882 585
R379 VSUB.n884 VSUB.n883 585
R380 VSUB.n479 VSUB.n478 585
R381 VSUB.n885 VSUB.n479 585
R382 VSUB.n888 VSUB.n887 585
R383 VSUB.n887 VSUB.n886 585
R384 VSUB.n889 VSUB.n473 585
R385 VSUB.n473 VSUB.n472 585
R386 VSUB.n891 VSUB.n890 585
R387 VSUB.n892 VSUB.n891 585
R388 VSUB.n471 VSUB.n470 585
R389 VSUB.n893 VSUB.n471 585
R390 VSUB.n896 VSUB.n895 585
R391 VSUB.n895 VSUB.n894 585
R392 VSUB.n897 VSUB.n465 585
R393 VSUB.n465 VSUB.n464 585
R394 VSUB.n899 VSUB.n898 585
R395 VSUB.n900 VSUB.n899 585
R396 VSUB.n463 VSUB.n462 585
R397 VSUB.n901 VSUB.n463 585
R398 VSUB.n904 VSUB.n903 585
R399 VSUB.n903 VSUB.n902 585
R400 VSUB.n905 VSUB.n457 585
R401 VSUB.n457 VSUB.n456 585
R402 VSUB.n907 VSUB.n906 585
R403 VSUB.n908 VSUB.n907 585
R404 VSUB.n451 VSUB.n450 585
R405 VSUB.n910 VSUB.n451 585
R406 VSUB.n913 VSUB.n912 585
R407 VSUB.n912 VSUB.n911 585
R408 VSUB.n914 VSUB.n445 585
R409 VSUB.n445 VSUB.n444 585
R410 VSUB.n916 VSUB.n915 585
R411 VSUB.n917 VSUB.n916 585
R412 VSUB.n443 VSUB.n442 585
R413 VSUB.n918 VSUB.n443 585
R414 VSUB.n921 VSUB.n920 585
R415 VSUB.n920 VSUB.n919 585
R416 VSUB.n922 VSUB.n437 585
R417 VSUB.n437 VSUB.n436 585
R418 VSUB.n924 VSUB.n923 585
R419 VSUB.n925 VSUB.n924 585
R420 VSUB.n435 VSUB.n434 585
R421 VSUB.n926 VSUB.n435 585
R422 VSUB.n929 VSUB.n928 585
R423 VSUB.n928 VSUB.n927 585
R424 VSUB.n930 VSUB.n429 585
R425 VSUB.n429 VSUB.n428 585
R426 VSUB.n932 VSUB.n931 585
R427 VSUB.n933 VSUB.n932 585
R428 VSUB.n427 VSUB.n426 585
R429 VSUB.n934 VSUB.n427 585
R430 VSUB.n937 VSUB.n936 585
R431 VSUB.n936 VSUB.n935 585
R432 VSUB.n938 VSUB.n421 585
R433 VSUB.n421 VSUB.n420 585
R434 VSUB.n940 VSUB.n939 585
R435 VSUB.n941 VSUB.n940 585
R436 VSUB.n419 VSUB.n418 585
R437 VSUB.n942 VSUB.n419 585
R438 VSUB.n945 VSUB.n944 585
R439 VSUB.n944 VSUB.n943 585
R440 VSUB.n946 VSUB.n413 585
R441 VSUB.n413 VSUB.n412 585
R442 VSUB.n948 VSUB.n947 585
R443 VSUB.n949 VSUB.n948 585
R444 VSUB.n411 VSUB.n410 585
R445 VSUB.n950 VSUB.n411 585
R446 VSUB.n953 VSUB.n952 585
R447 VSUB.n952 VSUB.n951 585
R448 VSUB.n954 VSUB.n405 585
R449 VSUB.n405 VSUB.n404 585
R450 VSUB.n956 VSUB.n955 585
R451 VSUB.n957 VSUB.n956 585
R452 VSUB.n683 VSUB.n682 585
R453 VSUB.n678 VSUB.n677 585
R454 VSUB.n684 VSUB.n678 585
R455 VSUB.n687 VSUB.n686 585
R456 VSUB.n686 VSUB.n685 585
R457 VSUB.n688 VSUB.n672 585
R458 VSUB.n679 VSUB.n672 585
R459 VSUB.n690 VSUB.n689 585
R460 VSUB.n691 VSUB.n690 585
R461 VSUB.n671 VSUB.n670 585
R462 VSUB.n692 VSUB.n671 585
R463 VSUB.n695 VSUB.n694 585
R464 VSUB.n694 VSUB.n693 585
R465 VSUB.n696 VSUB.n665 585
R466 VSUB.n665 VSUB.n664 585
R467 VSUB.n698 VSUB.n697 585
R468 VSUB.n699 VSUB.n698 585
R469 VSUB.n663 VSUB.n662 585
R470 VSUB.n700 VSUB.n663 585
R471 VSUB.n703 VSUB.n702 585
R472 VSUB.n702 VSUB.n701 585
R473 VSUB.n704 VSUB.n657 585
R474 VSUB.n657 VSUB.n656 585
R475 VSUB.n706 VSUB.n705 585
R476 VSUB.n707 VSUB.n706 585
R477 VSUB.n655 VSUB.n654 585
R478 VSUB.n708 VSUB.n655 585
R479 VSUB.n711 VSUB.n710 585
R480 VSUB.n710 VSUB.n709 585
R481 VSUB.n712 VSUB.n649 585
R482 VSUB.n649 VSUB.n648 585
R483 VSUB.n714 VSUB.n713 585
R484 VSUB.n715 VSUB.n714 585
R485 VSUB.n647 VSUB.n646 585
R486 VSUB.n716 VSUB.n647 585
R487 VSUB.n719 VSUB.n718 585
R488 VSUB.n718 VSUB.n717 585
R489 VSUB.n720 VSUB.n641 585
R490 VSUB.n641 VSUB.n640 585
R491 VSUB.n722 VSUB.n721 585
R492 VSUB.n723 VSUB.n722 585
R493 VSUB.n638 VSUB.n637 585
R494 VSUB.n724 VSUB.n638 585
R495 VSUB.n727 VSUB.n726 585
R496 VSUB.n726 VSUB.n725 585
R497 VSUB.n728 VSUB.n632 585
R498 VSUB.n639 VSUB.n632 585
R499 VSUB.n730 VSUB.n729 585
R500 VSUB.n731 VSUB.n730 585
R501 VSUB.n630 VSUB.n629 585
R502 VSUB.n732 VSUB.n630 585
R503 VSUB.n735 VSUB.n734 585
R504 VSUB.n734 VSUB.n733 585
R505 VSUB.n736 VSUB.n624 585
R506 VSUB.n631 VSUB.n624 585
R507 VSUB.n738 VSUB.n737 585
R508 VSUB.n739 VSUB.n738 585
R509 VSUB.n623 VSUB.n622 585
R510 VSUB.n740 VSUB.n623 585
R511 VSUB.n743 VSUB.n742 585
R512 VSUB.n742 VSUB.n741 585
R513 VSUB.n744 VSUB.n617 585
R514 VSUB.n617 VSUB.n616 585
R515 VSUB.n746 VSUB.n745 585
R516 VSUB.n747 VSUB.n746 585
R517 VSUB.n615 VSUB.n614 585
R518 VSUB.n748 VSUB.n615 585
R519 VSUB.n751 VSUB.n750 585
R520 VSUB.n750 VSUB.n749 585
R521 VSUB.n752 VSUB.n609 585
R522 VSUB.n609 VSUB.n608 585
R523 VSUB.n754 VSUB.n753 585
R524 VSUB.n755 VSUB.n754 585
R525 VSUB.n607 VSUB.n606 585
R526 VSUB.n756 VSUB.n607 585
R527 VSUB.n759 VSUB.n758 585
R528 VSUB.n758 VSUB.n757 585
R529 VSUB.n760 VSUB.n601 585
R530 VSUB.n601 VSUB.n600 585
R531 VSUB.n762 VSUB.n761 585
R532 VSUB.n763 VSUB.n762 585
R533 VSUB.n599 VSUB.n598 585
R534 VSUB.n764 VSUB.n599 585
R535 VSUB.n767 VSUB.n766 585
R536 VSUB.n766 VSUB.n765 585
R537 VSUB.n768 VSUB.n593 585
R538 VSUB.n593 VSUB.n592 585
R539 VSUB.n770 VSUB.n769 585
R540 VSUB.n771 VSUB.n770 585
R541 VSUB.n590 VSUB.n589 585
R542 VSUB.n772 VSUB.n590 585
R543 VSUB.n775 VSUB.n774 585
R544 VSUB.n774 VSUB.n773 585
R545 VSUB.n776 VSUB.n584 585
R546 VSUB.n591 VSUB.n584 585
R547 VSUB.n778 VSUB.n777 585
R548 VSUB.n779 VSUB.n778 585
R549 VSUB.n582 VSUB.n581 585
R550 VSUB.n780 VSUB.n582 585
R551 VSUB.n783 VSUB.n782 585
R552 VSUB.n782 VSUB.n781 585
R553 VSUB.n784 VSUB.n576 585
R554 VSUB.n583 VSUB.n576 585
R555 VSUB.n786 VSUB.n785 585
R556 VSUB.n787 VSUB.n786 585
R557 VSUB.n575 VSUB.n574 585
R558 VSUB.n788 VSUB.n575 585
R559 VSUB.n791 VSUB.n790 585
R560 VSUB.n790 VSUB.n789 585
R561 VSUB.n792 VSUB.n569 585
R562 VSUB.n569 VSUB.n568 585
R563 VSUB.n794 VSUB.n793 585
R564 VSUB.n795 VSUB.n794 585
R565 VSUB.n567 VSUB.n566 585
R566 VSUB.n796 VSUB.n567 585
R567 VSUB.n799 VSUB.n798 585
R568 VSUB.n798 VSUB.n797 585
R569 VSUB.n800 VSUB.n561 585
R570 VSUB.n561 VSUB.n560 585
R571 VSUB.n802 VSUB.n801 585
R572 VSUB.n803 VSUB.n802 585
R573 VSUB.n559 VSUB.n558 585
R574 VSUB.n804 VSUB.n559 585
R575 VSUB.n807 VSUB.n806 585
R576 VSUB.n806 VSUB.n805 585
R577 VSUB.n808 VSUB.n553 585
R578 VSUB.n553 VSUB.n552 585
R579 VSUB.n810 VSUB.n809 585
R580 VSUB.n811 VSUB.n810 585
R581 VSUB.n551 VSUB.n550 585
R582 VSUB.n812 VSUB.n551 585
R583 VSUB.n815 VSUB.n814 585
R584 VSUB.n814 VSUB.n813 585
R585 VSUB.n816 VSUB.n545 585
R586 VSUB.n545 VSUB.n544 585
R587 VSUB.n818 VSUB.n817 585
R588 VSUB.n819 VSUB.n818 585
R589 VSUB.n542 VSUB.n541 585
R590 VSUB.n820 VSUB.n542 585
R591 VSUB.n823 VSUB.n822 585
R592 VSUB.n822 VSUB.n821 585
R593 VSUB.n824 VSUB.n536 585
R594 VSUB.n543 VSUB.n536 585
R595 VSUB.n826 VSUB.n825 585
R596 VSUB.n827 VSUB.n826 585
R597 VSUB.n534 VSUB.n533 585
R598 VSUB.n828 VSUB.n534 585
R599 VSUB.n831 VSUB.n830 585
R600 VSUB.n830 VSUB.n829 585
R601 VSUB.n832 VSUB.n528 585
R602 VSUB.n535 VSUB.n528 585
R603 VSUB.n834 VSUB.n833 585
R604 VSUB.n835 VSUB.n834 585
R605 VSUB.n527 VSUB.n526 585
R606 VSUB.n836 VSUB.n527 585
R607 VSUB.n839 VSUB.n838 585
R608 VSUB.n838 VSUB.n837 585
R609 VSUB.n840 VSUB.n521 585
R610 VSUB.n521 VSUB.n520 585
R611 VSUB.n842 VSUB.n841 585
R612 VSUB.n843 VSUB.n842 585
R613 VSUB.n519 VSUB.n518 585
R614 VSUB.n844 VSUB.n519 585
R615 VSUB.n847 VSUB.n846 585
R616 VSUB.n846 VSUB.n845 585
R617 VSUB.n848 VSUB.n513 585
R618 VSUB.n513 VSUB.n512 585
R619 VSUB.n850 VSUB.n849 585
R620 VSUB.n851 VSUB.n850 585
R621 VSUB.n511 VSUB.n510 585
R622 VSUB.n852 VSUB.n511 585
R623 VSUB.n855 VSUB.n854 585
R624 VSUB.n854 VSUB.n853 585
R625 VSUB.n856 VSUB.n505 585
R626 VSUB.n505 VSUB.n504 585
R627 VSUB.n858 VSUB.n857 585
R628 VSUB.n859 VSUB.n858 585
R629 VSUB.n957 VSUB.n404 415.094
R630 VSUB.n951 VSUB.n404 415.094
R631 VSUB.n951 VSUB.n950 415.094
R632 VSUB.n950 VSUB.n949 415.094
R633 VSUB.n949 VSUB.n412 415.094
R634 VSUB.n943 VSUB.n412 415.094
R635 VSUB.n943 VSUB.n942 415.094
R636 VSUB.n942 VSUB.n941 415.094
R637 VSUB.n941 VSUB.n420 415.094
R638 VSUB.n935 VSUB.n420 415.094
R639 VSUB.n935 VSUB.n934 415.094
R640 VSUB.n934 VSUB.n933 415.094
R641 VSUB.n933 VSUB.n428 415.094
R642 VSUB.n927 VSUB.n428 415.094
R643 VSUB.n927 VSUB.n926 415.094
R644 VSUB.n926 VSUB.n925 415.094
R645 VSUB.n925 VSUB.n436 415.094
R646 VSUB.n919 VSUB.n436 415.094
R647 VSUB.n919 VSUB.n918 415.094
R648 VSUB.n918 VSUB.n917 415.094
R649 VSUB.n917 VSUB.n444 415.094
R650 VSUB.n911 VSUB.n444 415.094
R651 VSUB.n911 VSUB.n910 415.094
R652 VSUB.n908 VSUB.n456 415.094
R653 VSUB.n902 VSUB.n456 415.094
R654 VSUB.n902 VSUB.n901 415.094
R655 VSUB.n901 VSUB.n900 415.094
R656 VSUB.n900 VSUB.n464 415.094
R657 VSUB.n894 VSUB.n464 415.094
R658 VSUB.n894 VSUB.n893 415.094
R659 VSUB.n893 VSUB.n892 415.094
R660 VSUB.n892 VSUB.n472 415.094
R661 VSUB.n886 VSUB.n472 415.094
R662 VSUB.n886 VSUB.n885 415.094
R663 VSUB.n885 VSUB.n884 415.094
R664 VSUB.n884 VSUB.n480 415.094
R665 VSUB.n878 VSUB.n480 415.094
R666 VSUB.n878 VSUB.n877 415.094
R667 VSUB.n877 VSUB.n876 415.094
R668 VSUB.n876 VSUB.n488 415.094
R669 VSUB.n870 VSUB.n488 415.094
R670 VSUB.n870 VSUB.n869 415.094
R671 VSUB.n869 VSUB.n868 415.094
R672 VSUB.n868 VSUB.n496 415.094
R673 VSUB.n862 VSUB.n496 415.094
R674 VSUB.n862 VSUB.n861 415.094
R675 VSUB.n958 VSUB.n957 304.892
R676 VSUB.n909 VSUB.n908 290.567
R677 VSUB.n116 VSUB.n108 250.349
R678 VSUB.n1238 VSUB.n108 250.349
R679 VSUB.n1241 VSUB.n108 250.349
R680 VSUB.n108 VSUB.n5 250.349
R681 VSUB.n108 VSUB.n6 250.349
R682 VSUB.n108 VSUB.n7 250.349
R683 VSUB.n108 VSUB.n8 250.349
R684 VSUB.n108 VSUB.n9 250.349
R685 VSUB.n108 VSUB.n10 250.349
R686 VSUB.n108 VSUB.n11 250.349
R687 VSUB.n108 VSUB.n12 250.349
R688 VSUB.n108 VSUB.n13 250.349
R689 VSUB.n108 VSUB.n14 250.349
R690 VSUB.n108 VSUB.n15 250.349
R691 VSUB.n108 VSUB.n16 250.349
R692 VSUB.n108 VSUB.n17 250.349
R693 VSUB.n108 VSUB.n18 250.349
R694 VSUB.n108 VSUB.n19 250.349
R695 VSUB.n1197 VSUB.n155 250.349
R696 VSUB.n1197 VSUB.n156 250.349
R697 VSUB.n1197 VSUB.n157 250.349
R698 VSUB.n1197 VSUB.n158 250.349
R699 VSUB.n1197 VSUB.n159 250.349
R700 VSUB.n1197 VSUB.n1196 250.349
R701 VSUB.n1198 VSUB.n153 249.333
R702 VSUB.n1199 VSUB.n1198 220
R703 VSUB.n107 VSUB.n20 197
R704 VSUB.n103 VSUB.n102 197
R705 VSUB.n99 VSUB.n98 197
R706 VSUB.n95 VSUB.n94 197
R707 VSUB.n91 VSUB.n90 197
R708 VSUB.n87 VSUB.n86 197
R709 VSUB.n83 VSUB.n82 197
R710 VSUB.n79 VSUB.n78 197
R711 VSUB.n75 VSUB.n74 197
R712 VSUB.n71 VSUB.n70 197
R713 VSUB.n67 VSUB.n66 197
R714 VSUB.n63 VSUB.n62 197
R715 VSUB.n59 VSUB.n58 197
R716 VSUB.n55 VSUB.n54 197
R717 VSUB.n51 VSUB.n50 197
R718 VSUB.n1242 VSUB.n4 197
R719 VSUB.n1240 VSUB.n1239 197
R720 VSUB.n1237 VSUB.n110 197
R721 VSUB.n1233 VSUB.n1232 197
R722 VSUB.n1232 VSUB.n117 197
R723 VSUB.n1228 VSUB.n117 197
R724 VSUB.n1228 VSUB.n120 197
R725 VSUB.n1224 VSUB.n120 197
R726 VSUB.n1224 VSUB.n128 197
R727 VSUB.n1220 VSUB.n128 197
R728 VSUB.n1220 VSUB.n130 197
R729 VSUB.n1216 VSUB.n130 197
R730 VSUB.n1216 VSUB.n136 197
R731 VSUB.n1212 VSUB.n136 197
R732 VSUB.n1212 VSUB.n138 197
R733 VSUB.n1208 VSUB.n138 197
R734 VSUB.n1208 VSUB.n144 197
R735 VSUB.n1204 VSUB.n144 197
R736 VSUB.n1204 VSUB.n146 197
R737 VSUB.n1200 VSUB.n146 197
R738 VSUB.n1200 VSUB.n152 197
R739 VSUB.n160 VSUB.n152 197
R740 VSUB.n1195 VSUB.n161 197
R741 VSUB.n1191 VSUB.n1190 197
R742 VSUB.n1187 VSUB.n1186 197
R743 VSUB.n1183 VSUB.n1182 197
R744 VSUB.n1179 VSUB.n1178 197
R745 VSUB.n1175 VSUB.n1174 197
R746 VSUB.n1174 VSUB.n1173 197
R747 VSUB.n1173 VSUB.n177 197
R748 VSUB.n1169 VSUB.n177 197
R749 VSUB.n1169 VSUB.n180 197
R750 VSUB.n187 VSUB.n180 197
R751 VSUB.n188 VSUB.n187 197
R752 VSUB.n189 VSUB.n188 197
R753 VSUB.n208 VSUB.n189 197
R754 VSUB.n208 VSUB.n192 197
R755 VSUB.n193 VSUB.n192 197
R756 VSUB.n194 VSUB.n193 197
R757 VSUB.n213 VSUB.n194 197
R758 VSUB.n213 VSUB.n197 197
R759 VSUB.n198 VSUB.n197 197
R760 VSUB.n199 VSUB.n198 197
R761 VSUB.n203 VSUB.n199 197
R762 VSUB.n1145 VSUB.n203 197
R763 VSUB.n1145 VSUB.n204 197
R764 VSUB.n1141 VSUB.n204 197
R765 VSUB.n1141 VSUB.n220 197
R766 VSUB.n1137 VSUB.n220 197
R767 VSUB.n1137 VSUB.n225 197
R768 VSUB.n1132 VSUB.n225 197
R769 VSUB.n1132 VSUB.n228 197
R770 VSUB.n1128 VSUB.n228 197
R771 VSUB.n1128 VSUB.n234 197
R772 VSUB.n1124 VSUB.n234 197
R773 VSUB.n1124 VSUB.n236 197
R774 VSUB.n1120 VSUB.n236 197
R775 VSUB.n1120 VSUB.n242 197
R776 VSUB.n1116 VSUB.n242 197
R777 VSUB.n1116 VSUB.n244 197
R778 VSUB.n1112 VSUB.n244 197
R779 VSUB.n1112 VSUB.n250 197
R780 VSUB.n1108 VSUB.n250 197
R781 VSUB.n1108 VSUB.n252 197
R782 VSUB.n1104 VSUB.n252 197
R783 VSUB.n1104 VSUB.n258 197
R784 VSUB.n1100 VSUB.n258 197
R785 VSUB.n1100 VSUB.n260 197
R786 VSUB.n1096 VSUB.n260 197
R787 VSUB.n1096 VSUB.n266 197
R788 VSUB.n1092 VSUB.n266 197
R789 VSUB.n1092 VSUB.n268 197
R790 VSUB.n1088 VSUB.n268 197
R791 VSUB.n1088 VSUB.n274 197
R792 VSUB.n1084 VSUB.n274 197
R793 VSUB.n1084 VSUB.n276 197
R794 VSUB.n1080 VSUB.n276 197
R795 VSUB.n1080 VSUB.n282 197
R796 VSUB.n1076 VSUB.n282 197
R797 VSUB.n1076 VSUB.n284 197
R798 VSUB.n1072 VSUB.n284 197
R799 VSUB.n1072 VSUB.n290 197
R800 VSUB.n1068 VSUB.n290 197
R801 VSUB.n1068 VSUB.n292 197
R802 VSUB.n1064 VSUB.n292 197
R803 VSUB.n1064 VSUB.n298 197
R804 VSUB.n1060 VSUB.n298 197
R805 VSUB.n1060 VSUB.n300 197
R806 VSUB.n1056 VSUB.n300 197
R807 VSUB.n1056 VSUB.n306 197
R808 VSUB.n1052 VSUB.n306 197
R809 VSUB.n1052 VSUB.n308 197
R810 VSUB.n1048 VSUB.n308 197
R811 VSUB.n1048 VSUB.n314 197
R812 VSUB.n1044 VSUB.n314 197
R813 VSUB.n1044 VSUB.n316 197
R814 VSUB.n1040 VSUB.n316 197
R815 VSUB.n1040 VSUB.n322 197
R816 VSUB.n1036 VSUB.n322 197
R817 VSUB.n1036 VSUB.n324 197
R818 VSUB.n1032 VSUB.n324 197
R819 VSUB.n1032 VSUB.n330 197
R820 VSUB.n1028 VSUB.n330 197
R821 VSUB.n1028 VSUB.n332 197
R822 VSUB.n1024 VSUB.n332 197
R823 VSUB.n1024 VSUB.n338 197
R824 VSUB.n1020 VSUB.n338 197
R825 VSUB.n1020 VSUB.n340 197
R826 VSUB.n1016 VSUB.n340 197
R827 VSUB.n1016 VSUB.n346 197
R828 VSUB.n1012 VSUB.n346 197
R829 VSUB.n1012 VSUB.n348 197
R830 VSUB.n1008 VSUB.n348 197
R831 VSUB.n1008 VSUB.n354 197
R832 VSUB.n1004 VSUB.n354 197
R833 VSUB.n1004 VSUB.n356 197
R834 VSUB.n1000 VSUB.n356 197
R835 VSUB.n1000 VSUB.n362 197
R836 VSUB.n996 VSUB.n362 197
R837 VSUB.n996 VSUB.n364 197
R838 VSUB.n992 VSUB.n364 197
R839 VSUB.n992 VSUB.n370 197
R840 VSUB.n988 VSUB.n370 197
R841 VSUB.n988 VSUB.n372 197
R842 VSUB.n984 VSUB.n372 197
R843 VSUB.n984 VSUB.n378 197
R844 VSUB.n980 VSUB.n378 197
R845 VSUB.n980 VSUB.n380 197
R846 VSUB.n976 VSUB.n380 197
R847 VSUB.n976 VSUB.n386 197
R848 VSUB.n972 VSUB.n386 197
R849 VSUB.n972 VSUB.n388 197
R850 VSUB.n968 VSUB.n388 197
R851 VSUB.n968 VSUB.n394 197
R852 VSUB.n964 VSUB.n394 197
R853 VSUB.n964 VSUB.n396 197
R854 VSUB.n960 VSUB.n396 197
R855 VSUB.n960 VSUB.n402 197
R856 VSUB.n956 VSUB.n402 197
R857 VSUB.n956 VSUB.n405 197
R858 VSUB.n952 VSUB.n405 197
R859 VSUB.n952 VSUB.n411 197
R860 VSUB.n948 VSUB.n411 197
R861 VSUB.n948 VSUB.n413 197
R862 VSUB.n944 VSUB.n413 197
R863 VSUB.n944 VSUB.n419 197
R864 VSUB.n940 VSUB.n419 197
R865 VSUB.n940 VSUB.n421 197
R866 VSUB.n936 VSUB.n421 197
R867 VSUB.n936 VSUB.n427 197
R868 VSUB.n932 VSUB.n427 197
R869 VSUB.n932 VSUB.n429 197
R870 VSUB.n928 VSUB.n429 197
R871 VSUB.n928 VSUB.n435 197
R872 VSUB.n924 VSUB.n435 197
R873 VSUB.n924 VSUB.n437 197
R874 VSUB.n920 VSUB.n437 197
R875 VSUB.n920 VSUB.n443 197
R876 VSUB.n916 VSUB.n443 197
R877 VSUB.n916 VSUB.n445 197
R878 VSUB.n912 VSUB.n445 197
R879 VSUB.n912 VSUB.n451 197
R880 VSUB.n907 VSUB.n451 197
R881 VSUB.n907 VSUB.n457 197
R882 VSUB.n903 VSUB.n457 197
R883 VSUB.n903 VSUB.n463 197
R884 VSUB.n899 VSUB.n463 197
R885 VSUB.n899 VSUB.n465 197
R886 VSUB.n895 VSUB.n465 197
R887 VSUB.n895 VSUB.n471 197
R888 VSUB.n891 VSUB.n471 197
R889 VSUB.n891 VSUB.n473 197
R890 VSUB.n887 VSUB.n473 197
R891 VSUB.n887 VSUB.n479 197
R892 VSUB.n883 VSUB.n479 197
R893 VSUB.n883 VSUB.n481 197
R894 VSUB.n879 VSUB.n481 197
R895 VSUB.n879 VSUB.n487 197
R896 VSUB.n875 VSUB.n487 197
R897 VSUB.n875 VSUB.n489 197
R898 VSUB.n871 VSUB.n489 197
R899 VSUB.n871 VSUB.n495 197
R900 VSUB.n867 VSUB.n495 197
R901 VSUB.n867 VSUB.n497 197
R902 VSUB.n863 VSUB.n497 197
R903 VSUB.n863 VSUB.n503 197
R904 VSUB.n858 VSUB.n503 197
R905 VSUB.n858 VSUB.n505 197
R906 VSUB.n854 VSUB.n505 197
R907 VSUB.n854 VSUB.n511 197
R908 VSUB.n850 VSUB.n511 197
R909 VSUB.n850 VSUB.n513 197
R910 VSUB.n846 VSUB.n513 197
R911 VSUB.n846 VSUB.n519 197
R912 VSUB.n842 VSUB.n519 197
R913 VSUB.n842 VSUB.n521 197
R914 VSUB.n838 VSUB.n521 197
R915 VSUB.n838 VSUB.n527 197
R916 VSUB.n834 VSUB.n527 197
R917 VSUB.n834 VSUB.n528 197
R918 VSUB.n830 VSUB.n528 197
R919 VSUB.n830 VSUB.n534 197
R920 VSUB.n826 VSUB.n534 197
R921 VSUB.n826 VSUB.n536 197
R922 VSUB.n822 VSUB.n536 197
R923 VSUB.n822 VSUB.n542 197
R924 VSUB.n818 VSUB.n542 197
R925 VSUB.n818 VSUB.n545 197
R926 VSUB.n814 VSUB.n545 197
R927 VSUB.n814 VSUB.n551 197
R928 VSUB.n810 VSUB.n551 197
R929 VSUB.n810 VSUB.n553 197
R930 VSUB.n806 VSUB.n553 197
R931 VSUB.n806 VSUB.n559 197
R932 VSUB.n802 VSUB.n559 197
R933 VSUB.n802 VSUB.n561 197
R934 VSUB.n798 VSUB.n561 197
R935 VSUB.n798 VSUB.n567 197
R936 VSUB.n794 VSUB.n567 197
R937 VSUB.n794 VSUB.n569 197
R938 VSUB.n790 VSUB.n569 197
R939 VSUB.n790 VSUB.n575 197
R940 VSUB.n786 VSUB.n575 197
R941 VSUB.n786 VSUB.n576 197
R942 VSUB.n782 VSUB.n576 197
R943 VSUB.n782 VSUB.n582 197
R944 VSUB.n778 VSUB.n582 197
R945 VSUB.n778 VSUB.n584 197
R946 VSUB.n774 VSUB.n584 197
R947 VSUB.n774 VSUB.n590 197
R948 VSUB.n770 VSUB.n590 197
R949 VSUB.n770 VSUB.n593 197
R950 VSUB.n766 VSUB.n593 197
R951 VSUB.n766 VSUB.n599 197
R952 VSUB.n762 VSUB.n599 197
R953 VSUB.n762 VSUB.n601 197
R954 VSUB.n758 VSUB.n601 197
R955 VSUB.n758 VSUB.n607 197
R956 VSUB.n754 VSUB.n607 197
R957 VSUB.n754 VSUB.n609 197
R958 VSUB.n750 VSUB.n609 197
R959 VSUB.n750 VSUB.n615 197
R960 VSUB.n746 VSUB.n615 197
R961 VSUB.n746 VSUB.n617 197
R962 VSUB.n742 VSUB.n617 197
R963 VSUB.n742 VSUB.n623 197
R964 VSUB.n738 VSUB.n623 197
R965 VSUB.n738 VSUB.n624 197
R966 VSUB.n734 VSUB.n624 197
R967 VSUB.n734 VSUB.n630 197
R968 VSUB.n730 VSUB.n630 197
R969 VSUB.n730 VSUB.n632 197
R970 VSUB.n726 VSUB.n632 197
R971 VSUB.n726 VSUB.n638 197
R972 VSUB.n722 VSUB.n638 197
R973 VSUB.n722 VSUB.n641 197
R974 VSUB.n718 VSUB.n641 197
R975 VSUB.n718 VSUB.n647 197
R976 VSUB.n714 VSUB.n647 197
R977 VSUB.n714 VSUB.n649 197
R978 VSUB.n710 VSUB.n649 197
R979 VSUB.n710 VSUB.n655 197
R980 VSUB.n706 VSUB.n655 197
R981 VSUB.n706 VSUB.n657 197
R982 VSUB.n702 VSUB.n657 197
R983 VSUB.n702 VSUB.n663 197
R984 VSUB.n698 VSUB.n663 197
R985 VSUB.n698 VSUB.n665 197
R986 VSUB.n694 VSUB.n665 197
R987 VSUB.n694 VSUB.n671 197
R988 VSUB.n690 VSUB.n671 197
R989 VSUB.n690 VSUB.n672 197
R990 VSUB.n686 VSUB.n672 197
R991 VSUB.n686 VSUB.n678 197
R992 VSUB.n682 VSUB.n678 197
R993 VSUB.n1144 VSUB.n1143 194.69
R994 VSUB.n1143 VSUB.n1142 194.69
R995 VSUB.n1142 VSUB.n219 194.69
R996 VSUB.n1136 VSUB.n219 194.69
R997 VSUB.n1134 VSUB.n1133 194.69
R998 VSUB.n1133 VSUB.n227 194.69
R999 VSUB.n1127 VSUB.n227 194.69
R1000 VSUB.n1127 VSUB.n1126 194.69
R1001 VSUB.n1126 VSUB.n1125 194.69
R1002 VSUB.n1125 VSUB.n235 194.69
R1003 VSUB.n1119 VSUB.n235 194.69
R1004 VSUB.n1119 VSUB.n1118 194.69
R1005 VSUB.n1118 VSUB.n1117 194.69
R1006 VSUB.n1117 VSUB.n243 194.69
R1007 VSUB.n1111 VSUB.n243 194.69
R1008 VSUB.n1111 VSUB.n1110 194.69
R1009 VSUB.n1110 VSUB.n1109 194.69
R1010 VSUB.n1109 VSUB.n251 194.69
R1011 VSUB.n1103 VSUB.n251 194.69
R1012 VSUB.n1103 VSUB.n1102 194.69
R1013 VSUB.n1102 VSUB.n1101 194.69
R1014 VSUB.n1101 VSUB.n259 194.69
R1015 VSUB.n1095 VSUB.n259 194.69
R1016 VSUB.n1095 VSUB.n1094 194.69
R1017 VSUB.n1094 VSUB.n1093 194.69
R1018 VSUB.n1093 VSUB.n267 194.69
R1019 VSUB.n1087 VSUB.n267 194.69
R1020 VSUB.n1087 VSUB.n1086 194.69
R1021 VSUB.n1086 VSUB.n1085 194.69
R1022 VSUB.n1085 VSUB.n275 194.69
R1023 VSUB.n1079 VSUB.n275 194.69
R1024 VSUB.n1079 VSUB.n1078 194.69
R1025 VSUB.n1078 VSUB.n1077 194.69
R1026 VSUB.n1077 VSUB.n283 194.69
R1027 VSUB.n1071 VSUB.n283 194.69
R1028 VSUB.n1071 VSUB.n1070 194.69
R1029 VSUB.n1070 VSUB.n1069 194.69
R1030 VSUB.n1069 VSUB.n291 194.69
R1031 VSUB.n1063 VSUB.n291 194.69
R1032 VSUB.n1063 VSUB.n1062 194.69
R1033 VSUB.n1062 VSUB.n1061 194.69
R1034 VSUB.n1061 VSUB.n299 194.69
R1035 VSUB.n1055 VSUB.n299 194.69
R1036 VSUB.n1055 VSUB.n1054 194.69
R1037 VSUB.n1054 VSUB.n1053 194.69
R1038 VSUB.n1053 VSUB.n307 194.69
R1039 VSUB.n1047 VSUB.n307 194.69
R1040 VSUB.n1047 VSUB.n1046 194.69
R1041 VSUB.n1046 VSUB.n1045 194.69
R1042 VSUB.n1045 VSUB.n315 194.69
R1043 VSUB.n1039 VSUB.n315 194.69
R1044 VSUB.n1039 VSUB.n1038 194.69
R1045 VSUB.n1038 VSUB.n1037 194.69
R1046 VSUB.n1037 VSUB.n323 194.69
R1047 VSUB.n1031 VSUB.n323 194.69
R1048 VSUB.n1031 VSUB.n1030 194.69
R1049 VSUB.n1030 VSUB.n1029 194.69
R1050 VSUB.n1029 VSUB.n331 194.69
R1051 VSUB.n1023 VSUB.n331 194.69
R1052 VSUB.n1023 VSUB.n1022 194.69
R1053 VSUB.n1022 VSUB.n1021 194.69
R1054 VSUB.n1021 VSUB.n339 194.69
R1055 VSUB.n1015 VSUB.n339 194.69
R1056 VSUB.n1015 VSUB.n1014 194.69
R1057 VSUB.n1014 VSUB.n1013 194.69
R1058 VSUB.n1013 VSUB.n347 194.69
R1059 VSUB.n1007 VSUB.n347 194.69
R1060 VSUB.n1007 VSUB.n1006 194.69
R1061 VSUB.n1006 VSUB.n1005 194.69
R1062 VSUB.n1005 VSUB.n355 194.69
R1063 VSUB.n999 VSUB.n355 194.69
R1064 VSUB.n999 VSUB.n998 194.69
R1065 VSUB.n998 VSUB.n997 194.69
R1066 VSUB.n997 VSUB.n363 194.69
R1067 VSUB.n991 VSUB.n363 194.69
R1068 VSUB.n991 VSUB.n990 194.69
R1069 VSUB.n990 VSUB.n989 194.69
R1070 VSUB.n989 VSUB.n371 194.69
R1071 VSUB.n983 VSUB.n371 194.69
R1072 VSUB.n983 VSUB.n982 194.69
R1073 VSUB.n982 VSUB.n981 194.69
R1074 VSUB.n981 VSUB.n379 194.69
R1075 VSUB.n975 VSUB.n379 194.69
R1076 VSUB.n975 VSUB.n974 194.69
R1077 VSUB.n974 VSUB.n973 194.69
R1078 VSUB.n973 VSUB.n387 194.69
R1079 VSUB.n967 VSUB.n387 194.69
R1080 VSUB.n967 VSUB.n966 194.69
R1081 VSUB.n966 VSUB.n965 194.69
R1082 VSUB.n965 VSUB.n395 194.69
R1083 VSUB.n959 VSUB.n958 194.69
R1084 VSUB.n118 VSUB.n108 164.403
R1085 VSUB.n910 VSUB.n909 124.528
R1086 VSUB.n1136 VSUB.n1135 116.814
R1087 VSUB.n959 VSUB.n403 116.814
R1088 VSUB.n103 VSUB.n19 84.306
R1089 VSUB.n99 VSUB.n18 84.306
R1090 VSUB.n95 VSUB.n17 84.306
R1091 VSUB.n91 VSUB.n16 84.306
R1092 VSUB.n87 VSUB.n15 84.306
R1093 VSUB.n83 VSUB.n14 84.306
R1094 VSUB.n79 VSUB.n13 84.306
R1095 VSUB.n75 VSUB.n12 84.306
R1096 VSUB.n71 VSUB.n11 84.306
R1097 VSUB.n67 VSUB.n10 84.306
R1098 VSUB.n63 VSUB.n9 84.306
R1099 VSUB.n59 VSUB.n8 84.306
R1100 VSUB.n55 VSUB.n7 84.306
R1101 VSUB.n51 VSUB.n6 84.306
R1102 VSUB.n5 VSUB.n4 84.306
R1103 VSUB.n1241 VSUB.n1240 84.306
R1104 VSUB.n1238 VSUB.n1237 84.306
R1105 VSUB.n1233 VSUB.n116 84.306
R1106 VSUB.n1196 VSUB.n1195 84.306
R1107 VSUB.n1191 VSUB.n159 84.306
R1108 VSUB.n1187 VSUB.n158 84.306
R1109 VSUB.n1183 VSUB.n157 84.306
R1110 VSUB.n1179 VSUB.n156 84.306
R1111 VSUB.n1175 VSUB.n155 84.306
R1112 VSUB.n116 VSUB.n110 84.306
R1113 VSUB.n1239 VSUB.n1238 84.306
R1114 VSUB.n1242 VSUB.n1241 84.306
R1115 VSUB.n50 VSUB.n5 84.306
R1116 VSUB.n54 VSUB.n6 84.306
R1117 VSUB.n58 VSUB.n7 84.306
R1118 VSUB.n62 VSUB.n8 84.306
R1119 VSUB.n66 VSUB.n9 84.306
R1120 VSUB.n70 VSUB.n10 84.306
R1121 VSUB.n74 VSUB.n11 84.306
R1122 VSUB.n78 VSUB.n12 84.306
R1123 VSUB.n82 VSUB.n13 84.306
R1124 VSUB.n86 VSUB.n14 84.306
R1125 VSUB.n90 VSUB.n15 84.306
R1126 VSUB.n94 VSUB.n16 84.306
R1127 VSUB.n98 VSUB.n17 84.306
R1128 VSUB.n102 VSUB.n18 84.306
R1129 VSUB.n20 VSUB.n19 84.306
R1130 VSUB.n1178 VSUB.n155 84.306
R1131 VSUB.n1182 VSUB.n156 84.306
R1132 VSUB.n1186 VSUB.n157 84.306
R1133 VSUB.n1190 VSUB.n158 84.306
R1134 VSUB.n161 VSUB.n159 84.306
R1135 VSUB.n1196 VSUB.n160 84.306
R1136 VSUB.n1135 VSUB.n1134 77.8766
R1137 VSUB.n403 VSUB.n395 77.8766
R1138 VSUB.n859 VSUB.n504 45.8052
R1139 VSUB.n853 VSUB.n504 45.8052
R1140 VSUB.n852 VSUB.n851 45.8052
R1141 VSUB.n851 VSUB.n512 45.8052
R1142 VSUB.n845 VSUB.n512 45.8052
R1143 VSUB.n845 VSUB.n844 45.8052
R1144 VSUB.n843 VSUB.n520 45.8052
R1145 VSUB.n837 VSUB.n520 45.8052
R1146 VSUB.n837 VSUB.n836 45.8052
R1147 VSUB.n836 VSUB.n835 45.8052
R1148 VSUB.n829 VSUB.n535 45.8052
R1149 VSUB.n829 VSUB.n828 45.8052
R1150 VSUB.n828 VSUB.n827 45.8052
R1151 VSUB.n821 VSUB.n543 45.8052
R1152 VSUB.n821 VSUB.n820 45.8052
R1153 VSUB.n820 VSUB.n819 45.8052
R1154 VSUB.n819 VSUB.n544 45.8052
R1155 VSUB.n813 VSUB.n812 45.8052
R1156 VSUB.n812 VSUB.n811 45.8052
R1157 VSUB.n811 VSUB.n552 45.8052
R1158 VSUB.n805 VSUB.n552 45.8052
R1159 VSUB.n804 VSUB.n803 45.8052
R1160 VSUB.n803 VSUB.n560 45.8052
R1161 VSUB.n797 VSUB.n560 45.8052
R1162 VSUB.n797 VSUB.n796 45.8052
R1163 VSUB.n795 VSUB.n568 45.8052
R1164 VSUB.n789 VSUB.n568 45.8052
R1165 VSUB.n789 VSUB.n788 45.8052
R1166 VSUB.n788 VSUB.n787 45.8052
R1167 VSUB.n781 VSUB.n583 45.8052
R1168 VSUB.n781 VSUB.n780 45.8052
R1169 VSUB.n780 VSUB.n779 45.8052
R1170 VSUB.n773 VSUB.n591 45.8052
R1171 VSUB.n773 VSUB.n772 45.8052
R1172 VSUB.n772 VSUB.n771 45.8052
R1173 VSUB.n771 VSUB.n592 45.8052
R1174 VSUB.n765 VSUB.n764 45.8052
R1175 VSUB.n764 VSUB.n763 45.8052
R1176 VSUB.n763 VSUB.n600 45.8052
R1177 VSUB.n757 VSUB.n600 45.8052
R1178 VSUB.n756 VSUB.n755 45.8052
R1179 VSUB.n755 VSUB.n608 45.8052
R1180 VSUB.n749 VSUB.n608 45.8052
R1181 VSUB.n749 VSUB.n748 45.8052
R1182 VSUB.n747 VSUB.n616 45.8052
R1183 VSUB.n741 VSUB.n616 45.8052
R1184 VSUB.n741 VSUB.n740 45.8052
R1185 VSUB.n740 VSUB.n739 45.8052
R1186 VSUB.n733 VSUB.n631 45.8052
R1187 VSUB.n733 VSUB.n732 45.8052
R1188 VSUB.n732 VSUB.n731 45.8052
R1189 VSUB.n725 VSUB.n639 45.8052
R1190 VSUB.n725 VSUB.n724 45.8052
R1191 VSUB.n724 VSUB.n723 45.8052
R1192 VSUB.n723 VSUB.n640 45.8052
R1193 VSUB.n717 VSUB.n716 45.8052
R1194 VSUB.n716 VSUB.n715 45.8052
R1195 VSUB.n715 VSUB.n648 45.8052
R1196 VSUB.n709 VSUB.n648 45.8052
R1197 VSUB.n708 VSUB.n707 45.8052
R1198 VSUB.n707 VSUB.n656 45.8052
R1199 VSUB.n701 VSUB.n656 45.8052
R1200 VSUB.n701 VSUB.n700 45.8052
R1201 VSUB.n699 VSUB.n664 45.8052
R1202 VSUB.n693 VSUB.n664 45.8052
R1203 VSUB.n693 VSUB.n692 45.8052
R1204 VSUB.n692 VSUB.n691 45.8052
R1205 VSUB.n685 VSUB.n679 45.8052
R1206 VSUB.n685 VSUB.n684 45.8052
R1207 VSUB.n684 VSUB.n683 45.8052
R1208 VSUB.n861 VSUB.n860 41.5099
R1209 VSUB.n860 VSUB.n859 41.2247
R1210 VSUB.n535 VSUB.t17 41.2247
R1211 VSUB.n827 VSUB.t14 41.2247
R1212 VSUB.n583 VSUB.t8 41.2247
R1213 VSUB.n779 VSUB.t11 41.2247
R1214 VSUB.n631 VSUB.t16 41.2247
R1215 VSUB.n731 VSUB.t9 41.2247
R1216 VSUB.n679 VSUB.t13 41.2247
R1217 VSUB.n683 VSUB.t7 41.2247
R1218 VSUB.t7 VSUB.n680 36.6443
R1219 VSUB VSUB.t5 34.8056
R1220 VSUB.n1246 VSUB.t18 33.9458
R1221 VSUB.t6 VSUB.n843 32.0638
R1222 VSUB.t3 VSUB.n544 32.0638
R1223 VSUB.t19 VSUB.n795 32.0638
R1224 VSUB.t20 VSUB.n592 32.0638
R1225 VSUB.t0 VSUB.n747 32.0638
R1226 VSUB.t2 VSUB.n640 32.0638
R1227 VSUB.t10 VSUB.n699 32.0638
R1228 VSUB.n853 VSUB.t12 22.9029
R1229 VSUB.t12 VSUB.n852 22.9029
R1230 VSUB.n805 VSUB.t4 22.9029
R1231 VSUB.t4 VSUB.n804 22.9029
R1232 VSUB.n757 VSUB.t1 22.9029
R1233 VSUB.t1 VSUB.n756 22.9029
R1234 VSUB.n709 VSUB.t15 22.9029
R1235 VSUB.t15 VSUB.n708 22.9029
R1236 VSUB.n1246 VSUB.n1245 20.8745
R1237 VSUB.n104 VSUB.n21 16.0005
R1238 VSUB.n104 VSUB.n101 16.0005
R1239 VSUB.n101 VSUB.n100 16.0005
R1240 VSUB.n100 VSUB.n97 16.0005
R1241 VSUB.n97 VSUB.n96 16.0005
R1242 VSUB.n96 VSUB.n93 16.0005
R1243 VSUB.n93 VSUB.n92 16.0005
R1244 VSUB.n92 VSUB.n89 16.0005
R1245 VSUB.n89 VSUB.n88 16.0005
R1246 VSUB.n88 VSUB.n85 16.0005
R1247 VSUB.n85 VSUB.n84 16.0005
R1248 VSUB.n84 VSUB.n81 16.0005
R1249 VSUB.n81 VSUB.n80 16.0005
R1250 VSUB.n80 VSUB.n77 16.0005
R1251 VSUB.n77 VSUB.n76 16.0005
R1252 VSUB.n76 VSUB.n73 16.0005
R1253 VSUB.n73 VSUB.n72 16.0005
R1254 VSUB.n72 VSUB.n69 16.0005
R1255 VSUB.n69 VSUB.n68 16.0005
R1256 VSUB.n68 VSUB.n65 16.0005
R1257 VSUB.n65 VSUB.n64 16.0005
R1258 VSUB.n64 VSUB.n61 16.0005
R1259 VSUB.n61 VSUB.n60 16.0005
R1260 VSUB.n60 VSUB.n57 16.0005
R1261 VSUB.n57 VSUB.n56 16.0005
R1262 VSUB.n56 VSUB.n53 16.0005
R1263 VSUB.n53 VSUB.n52 16.0005
R1264 VSUB.n52 VSUB.n49 16.0005
R1265 VSUB.n49 VSUB.n2 16.0005
R1266 VSUB.n1243 VSUB.n2 16.0005
R1267 VSUB.n1243 VSUB.n3 16.0005
R1268 VSUB.n109 VSUB.n3 16.0005
R1269 VSUB.n1236 VSUB.n109 16.0005
R1270 VSUB.n1236 VSUB.n1235 16.0005
R1271 VSUB.n1235 VSUB.n1234 16.0005
R1272 VSUB.n1234 VSUB.n115 16.0005
R1273 VSUB.n121 VSUB.n115 16.0005
R1274 VSUB.n1227 VSUB.n121 16.0005
R1275 VSUB.n1227 VSUB.n1226 16.0005
R1276 VSUB.n1226 VSUB.n1225 16.0005
R1277 VSUB.n1225 VSUB.n127 16.0005
R1278 VSUB.n1219 VSUB.n127 16.0005
R1279 VSUB.n1219 VSUB.n1218 16.0005
R1280 VSUB.n1218 VSUB.n1217 16.0005
R1281 VSUB.n1217 VSUB.n135 16.0005
R1282 VSUB.n1211 VSUB.n135 16.0005
R1283 VSUB.n1211 VSUB.n1210 16.0005
R1284 VSUB.n1210 VSUB.n1209 16.0005
R1285 VSUB.n1209 VSUB.n143 16.0005
R1286 VSUB.n1203 VSUB.n143 16.0005
R1287 VSUB.n1203 VSUB.n1202 16.0005
R1288 VSUB.n1202 VSUB.n1201 16.0005
R1289 VSUB.n1201 VSUB.n151 16.0005
R1290 VSUB.n162 VSUB.n151 16.0005
R1291 VSUB.n1194 VSUB.n162 16.0005
R1292 VSUB.n1194 VSUB.n1193 16.0005
R1293 VSUB.n1193 VSUB.n1192 16.0005
R1294 VSUB.n1192 VSUB.n1189 16.0005
R1295 VSUB.n1189 VSUB.n1188 16.0005
R1296 VSUB.n1188 VSUB.n1185 16.0005
R1297 VSUB.n1185 VSUB.n1184 16.0005
R1298 VSUB.n1184 VSUB.n1181 16.0005
R1299 VSUB.n1181 VSUB.n1180 16.0005
R1300 VSUB.n1180 VSUB.n1177 16.0005
R1301 VSUB.n1177 VSUB.n1176 16.0005
R1302 VSUB.n1176 VSUB.n176 16.0005
R1303 VSUB.n178 VSUB.n176 16.0005
R1304 VSUB.n181 VSUB.n178 16.0005
R1305 VSUB.n1168 VSUB.n181 16.0005
R1306 VSUB.n1168 VSUB.n182 16.0005
R1307 VSUB.n1164 VSUB.n182 16.0005
R1308 VSUB.n1164 VSUB.n1163 16.0005
R1309 VSUB.n1163 VSUB.n1162 16.0005
R1310 VSUB.n1162 VSUB.n190 16.0005
R1311 VSUB.n1158 VSUB.n190 16.0005
R1312 VSUB.n1158 VSUB.n1157 16.0005
R1313 VSUB.n1157 VSUB.n1156 16.0005
R1314 VSUB.n1156 VSUB.n195 16.0005
R1315 VSUB.n1152 VSUB.n195 16.0005
R1316 VSUB.n1152 VSUB.n1151 16.0005
R1317 VSUB.n1151 VSUB.n1150 16.0005
R1318 VSUB.n1150 VSUB.n200 16.0005
R1319 VSUB.n1146 VSUB.n200 16.0005
R1320 VSUB.n1146 VSUB.n202 16.0005
R1321 VSUB.n1140 VSUB.n202 16.0005
R1322 VSUB.n1140 VSUB.n1139 16.0005
R1323 VSUB.n1139 VSUB.n1138 16.0005
R1324 VSUB.n1138 VSUB.n224 16.0005
R1325 VSUB.n1131 VSUB.n224 16.0005
R1326 VSUB.n1131 VSUB.n1130 16.0005
R1327 VSUB.n1130 VSUB.n1129 16.0005
R1328 VSUB.n1129 VSUB.n233 16.0005
R1329 VSUB.n1123 VSUB.n233 16.0005
R1330 VSUB.n1123 VSUB.n1122 16.0005
R1331 VSUB.n1122 VSUB.n1121 16.0005
R1332 VSUB.n1121 VSUB.n241 16.0005
R1333 VSUB.n1115 VSUB.n241 16.0005
R1334 VSUB.n1115 VSUB.n1114 16.0005
R1335 VSUB.n1114 VSUB.n1113 16.0005
R1336 VSUB.n1113 VSUB.n249 16.0005
R1337 VSUB.n1107 VSUB.n249 16.0005
R1338 VSUB.n1107 VSUB.n1106 16.0005
R1339 VSUB.n1106 VSUB.n1105 16.0005
R1340 VSUB.n1105 VSUB.n257 16.0005
R1341 VSUB.n1099 VSUB.n257 16.0005
R1342 VSUB.n1099 VSUB.n1098 16.0005
R1343 VSUB.n1098 VSUB.n1097 16.0005
R1344 VSUB.n1097 VSUB.n265 16.0005
R1345 VSUB.n1091 VSUB.n265 16.0005
R1346 VSUB.n1091 VSUB.n1090 16.0005
R1347 VSUB.n1090 VSUB.n1089 16.0005
R1348 VSUB.n1089 VSUB.n273 16.0005
R1349 VSUB.n1083 VSUB.n273 16.0005
R1350 VSUB.n1083 VSUB.n1082 16.0005
R1351 VSUB.n1082 VSUB.n1081 16.0005
R1352 VSUB.n1081 VSUB.n281 16.0005
R1353 VSUB.n1075 VSUB.n281 16.0005
R1354 VSUB.n1075 VSUB.n1074 16.0005
R1355 VSUB.n1074 VSUB.n1073 16.0005
R1356 VSUB.n1073 VSUB.n289 16.0005
R1357 VSUB.n1067 VSUB.n289 16.0005
R1358 VSUB.n1067 VSUB.n1066 16.0005
R1359 VSUB.n1066 VSUB.n1065 16.0005
R1360 VSUB.n1065 VSUB.n297 16.0005
R1361 VSUB.n1059 VSUB.n297 16.0005
R1362 VSUB.n1059 VSUB.n1058 16.0005
R1363 VSUB.n1058 VSUB.n1057 16.0005
R1364 VSUB.n1057 VSUB.n305 16.0005
R1365 VSUB.n1051 VSUB.n305 16.0005
R1366 VSUB.n1051 VSUB.n1050 16.0005
R1367 VSUB.n1050 VSUB.n1049 16.0005
R1368 VSUB.n1049 VSUB.n313 16.0005
R1369 VSUB.n1043 VSUB.n313 16.0005
R1370 VSUB.n1043 VSUB.n1042 16.0005
R1371 VSUB.n1042 VSUB.n1041 16.0005
R1372 VSUB.n1041 VSUB.n321 16.0005
R1373 VSUB.n1035 VSUB.n321 16.0005
R1374 VSUB.n1035 VSUB.n1034 16.0005
R1375 VSUB.n1034 VSUB.n1033 16.0005
R1376 VSUB.n1033 VSUB.n329 16.0005
R1377 VSUB.n1027 VSUB.n329 16.0005
R1378 VSUB.n1027 VSUB.n1026 16.0005
R1379 VSUB.n1026 VSUB.n1025 16.0005
R1380 VSUB.n1025 VSUB.n337 16.0005
R1381 VSUB.n1019 VSUB.n337 16.0005
R1382 VSUB.n1019 VSUB.n1018 16.0005
R1383 VSUB.n1018 VSUB.n1017 16.0005
R1384 VSUB.n1017 VSUB.n345 16.0005
R1385 VSUB.n1011 VSUB.n345 16.0005
R1386 VSUB.n1011 VSUB.n1010 16.0005
R1387 VSUB.n1010 VSUB.n1009 16.0005
R1388 VSUB.n1009 VSUB.n353 16.0005
R1389 VSUB.n1003 VSUB.n353 16.0005
R1390 VSUB.n1003 VSUB.n1002 16.0005
R1391 VSUB.n1002 VSUB.n1001 16.0005
R1392 VSUB.n1001 VSUB.n361 16.0005
R1393 VSUB.n995 VSUB.n361 16.0005
R1394 VSUB.n995 VSUB.n994 16.0005
R1395 VSUB.n994 VSUB.n993 16.0005
R1396 VSUB.n993 VSUB.n369 16.0005
R1397 VSUB.n987 VSUB.n369 16.0005
R1398 VSUB.n987 VSUB.n986 16.0005
R1399 VSUB.n986 VSUB.n985 16.0005
R1400 VSUB.n985 VSUB.n377 16.0005
R1401 VSUB.n979 VSUB.n377 16.0005
R1402 VSUB.n979 VSUB.n978 16.0005
R1403 VSUB.n978 VSUB.n977 16.0005
R1404 VSUB.n977 VSUB.n385 16.0005
R1405 VSUB.n971 VSUB.n385 16.0005
R1406 VSUB.n971 VSUB.n970 16.0005
R1407 VSUB.n970 VSUB.n969 16.0005
R1408 VSUB.n969 VSUB.n393 16.0005
R1409 VSUB.n963 VSUB.n393 16.0005
R1410 VSUB.n963 VSUB.n962 16.0005
R1411 VSUB.n962 VSUB.n961 16.0005
R1412 VSUB.n961 VSUB.n401 16.0005
R1413 VSUB.n955 VSUB.n401 16.0005
R1414 VSUB.n955 VSUB.n954 16.0005
R1415 VSUB.n954 VSUB.n953 16.0005
R1416 VSUB.n953 VSUB.n410 16.0005
R1417 VSUB.n947 VSUB.n410 16.0005
R1418 VSUB.n947 VSUB.n946 16.0005
R1419 VSUB.n946 VSUB.n945 16.0005
R1420 VSUB.n945 VSUB.n418 16.0005
R1421 VSUB.n939 VSUB.n418 16.0005
R1422 VSUB.n939 VSUB.n938 16.0005
R1423 VSUB.n938 VSUB.n937 16.0005
R1424 VSUB.n937 VSUB.n426 16.0005
R1425 VSUB.n931 VSUB.n426 16.0005
R1426 VSUB.n931 VSUB.n930 16.0005
R1427 VSUB.n930 VSUB.n929 16.0005
R1428 VSUB.n929 VSUB.n434 16.0005
R1429 VSUB.n923 VSUB.n434 16.0005
R1430 VSUB.n923 VSUB.n922 16.0005
R1431 VSUB.n922 VSUB.n921 16.0005
R1432 VSUB.n921 VSUB.n442 16.0005
R1433 VSUB.n915 VSUB.n442 16.0005
R1434 VSUB.n915 VSUB.n914 16.0005
R1435 VSUB.n914 VSUB.n913 16.0005
R1436 VSUB.n913 VSUB.n450 16.0005
R1437 VSUB.n906 VSUB.n450 16.0005
R1438 VSUB.n906 VSUB.n905 16.0005
R1439 VSUB.n905 VSUB.n904 16.0005
R1440 VSUB.n904 VSUB.n462 16.0005
R1441 VSUB.n898 VSUB.n462 16.0005
R1442 VSUB.n898 VSUB.n897 16.0005
R1443 VSUB.n897 VSUB.n896 16.0005
R1444 VSUB.n896 VSUB.n470 16.0005
R1445 VSUB.n890 VSUB.n470 16.0005
R1446 VSUB.n890 VSUB.n889 16.0005
R1447 VSUB.n889 VSUB.n888 16.0005
R1448 VSUB.n888 VSUB.n478 16.0005
R1449 VSUB.n882 VSUB.n478 16.0005
R1450 VSUB.n882 VSUB.n881 16.0005
R1451 VSUB.n881 VSUB.n880 16.0005
R1452 VSUB.n880 VSUB.n486 16.0005
R1453 VSUB.n874 VSUB.n486 16.0005
R1454 VSUB.n874 VSUB.n873 16.0005
R1455 VSUB.n873 VSUB.n872 16.0005
R1456 VSUB.n872 VSUB.n494 16.0005
R1457 VSUB.n866 VSUB.n494 16.0005
R1458 VSUB.n866 VSUB.n865 16.0005
R1459 VSUB.n865 VSUB.n864 16.0005
R1460 VSUB.n864 VSUB.n502 16.0005
R1461 VSUB.n857 VSUB.n502 16.0005
R1462 VSUB.n857 VSUB.n856 16.0005
R1463 VSUB.n856 VSUB.n855 16.0005
R1464 VSUB.n855 VSUB.n510 16.0005
R1465 VSUB.n849 VSUB.n510 16.0005
R1466 VSUB.n849 VSUB.n848 16.0005
R1467 VSUB.n848 VSUB.n847 16.0005
R1468 VSUB.n847 VSUB.n518 16.0005
R1469 VSUB.n841 VSUB.n518 16.0005
R1470 VSUB.n841 VSUB.n840 16.0005
R1471 VSUB.n840 VSUB.n839 16.0005
R1472 VSUB.n839 VSUB.n526 16.0005
R1473 VSUB.n833 VSUB.n526 16.0005
R1474 VSUB.n833 VSUB.n832 16.0005
R1475 VSUB.n832 VSUB.n831 16.0005
R1476 VSUB.n831 VSUB.n533 16.0005
R1477 VSUB.n825 VSUB.n533 16.0005
R1478 VSUB.n825 VSUB.n824 16.0005
R1479 VSUB.n824 VSUB.n823 16.0005
R1480 VSUB.n823 VSUB.n541 16.0005
R1481 VSUB.n817 VSUB.n541 16.0005
R1482 VSUB.n817 VSUB.n816 16.0005
R1483 VSUB.n816 VSUB.n815 16.0005
R1484 VSUB.n815 VSUB.n550 16.0005
R1485 VSUB.n809 VSUB.n550 16.0005
R1486 VSUB.n809 VSUB.n808 16.0005
R1487 VSUB.n808 VSUB.n807 16.0005
R1488 VSUB.n807 VSUB.n558 16.0005
R1489 VSUB.n801 VSUB.n558 16.0005
R1490 VSUB.n801 VSUB.n800 16.0005
R1491 VSUB.n800 VSUB.n799 16.0005
R1492 VSUB.n799 VSUB.n566 16.0005
R1493 VSUB.n793 VSUB.n566 16.0005
R1494 VSUB.n793 VSUB.n792 16.0005
R1495 VSUB.n792 VSUB.n791 16.0005
R1496 VSUB.n791 VSUB.n574 16.0005
R1497 VSUB.n785 VSUB.n574 16.0005
R1498 VSUB.n785 VSUB.n784 16.0005
R1499 VSUB.n784 VSUB.n783 16.0005
R1500 VSUB.n783 VSUB.n581 16.0005
R1501 VSUB.n777 VSUB.n581 16.0005
R1502 VSUB.n777 VSUB.n776 16.0005
R1503 VSUB.n776 VSUB.n775 16.0005
R1504 VSUB.n775 VSUB.n589 16.0005
R1505 VSUB.n769 VSUB.n589 16.0005
R1506 VSUB.n769 VSUB.n768 16.0005
R1507 VSUB.n768 VSUB.n767 16.0005
R1508 VSUB.n767 VSUB.n598 16.0005
R1509 VSUB.n761 VSUB.n598 16.0005
R1510 VSUB.n761 VSUB.n760 16.0005
R1511 VSUB.n760 VSUB.n759 16.0005
R1512 VSUB.n759 VSUB.n606 16.0005
R1513 VSUB.n753 VSUB.n606 16.0005
R1514 VSUB.n753 VSUB.n752 16.0005
R1515 VSUB.n752 VSUB.n751 16.0005
R1516 VSUB.n751 VSUB.n614 16.0005
R1517 VSUB.n745 VSUB.n614 16.0005
R1518 VSUB.n745 VSUB.n744 16.0005
R1519 VSUB.n744 VSUB.n743 16.0005
R1520 VSUB.n743 VSUB.n622 16.0005
R1521 VSUB.n737 VSUB.n622 16.0005
R1522 VSUB.n737 VSUB.n736 16.0005
R1523 VSUB.n736 VSUB.n735 16.0005
R1524 VSUB.n735 VSUB.n629 16.0005
R1525 VSUB.n729 VSUB.n629 16.0005
R1526 VSUB.n729 VSUB.n728 16.0005
R1527 VSUB.n728 VSUB.n727 16.0005
R1528 VSUB.n727 VSUB.n637 16.0005
R1529 VSUB.n721 VSUB.n637 16.0005
R1530 VSUB.n721 VSUB.n720 16.0005
R1531 VSUB.n720 VSUB.n719 16.0005
R1532 VSUB.n719 VSUB.n646 16.0005
R1533 VSUB.n713 VSUB.n646 16.0005
R1534 VSUB.n713 VSUB.n712 16.0005
R1535 VSUB.n712 VSUB.n711 16.0005
R1536 VSUB.n711 VSUB.n654 16.0005
R1537 VSUB.n705 VSUB.n654 16.0005
R1538 VSUB.n705 VSUB.n704 16.0005
R1539 VSUB.n704 VSUB.n703 16.0005
R1540 VSUB.n703 VSUB.n662 16.0005
R1541 VSUB.n697 VSUB.n662 16.0005
R1542 VSUB.n697 VSUB.n696 16.0005
R1543 VSUB.n696 VSUB.n695 16.0005
R1544 VSUB.n695 VSUB.n670 16.0005
R1545 VSUB.n689 VSUB.n670 16.0005
R1546 VSUB.n689 VSUB.n688 16.0005
R1547 VSUB.n688 VSUB.n687 16.0005
R1548 VSUB.n687 VSUB.n677 16.0005
R1549 VSUB.n844 VSUB.t6 13.7419
R1550 VSUB.n813 VSUB.t3 13.7419
R1551 VSUB.n796 VSUB.t19 13.7419
R1552 VSUB.n765 VSUB.t20 13.7419
R1553 VSUB.n748 VSUB.t0 13.7419
R1554 VSUB.n717 VSUB.t2 13.7419
R1555 VSUB.n700 VSUB.t10 13.7419
R1556 VSUB.n105 VSUB.n104 9.3005
R1557 VSUB.n101 VSUB.n22 9.3005
R1558 VSUB.n100 VSUB.n23 9.3005
R1559 VSUB.n97 VSUB.n24 9.3005
R1560 VSUB.n96 VSUB.n25 9.3005
R1561 VSUB.n93 VSUB.n26 9.3005
R1562 VSUB.n92 VSUB.n27 9.3005
R1563 VSUB.n89 VSUB.n28 9.3005
R1564 VSUB.n88 VSUB.n29 9.3005
R1565 VSUB.n85 VSUB.n30 9.3005
R1566 VSUB.n84 VSUB.n31 9.3005
R1567 VSUB.n81 VSUB.n32 9.3005
R1568 VSUB.n80 VSUB.n33 9.3005
R1569 VSUB.n77 VSUB.n34 9.3005
R1570 VSUB.n76 VSUB.n35 9.3005
R1571 VSUB.n73 VSUB.n36 9.3005
R1572 VSUB.n72 VSUB.n37 9.3005
R1573 VSUB.n69 VSUB.n38 9.3005
R1574 VSUB.n68 VSUB.n39 9.3005
R1575 VSUB.n65 VSUB.n40 9.3005
R1576 VSUB.n64 VSUB.n41 9.3005
R1577 VSUB.n61 VSUB.n42 9.3005
R1578 VSUB.n60 VSUB.n43 9.3005
R1579 VSUB.n57 VSUB.n44 9.3005
R1580 VSUB.n56 VSUB.n45 9.3005
R1581 VSUB.n53 VSUB.n46 9.3005
R1582 VSUB.n52 VSUB.n47 9.3005
R1583 VSUB.n49 VSUB.n48 9.3005
R1584 VSUB.n2 VSUB.n0 9.3005
R1585 VSUB.n1244 VSUB.n1243 9.3005
R1586 VSUB.n3 VSUB.n1 9.3005
R1587 VSUB.n111 VSUB.n109 9.3005
R1588 VSUB.n1236 VSUB.n112 9.3005
R1589 VSUB.n1235 VSUB.n113 9.3005
R1590 VSUB.n1234 VSUB.n114 9.3005
R1591 VSUB.n122 VSUB.n115 9.3005
R1592 VSUB.n123 VSUB.n121 9.3005
R1593 VSUB.n1227 VSUB.n124 9.3005
R1594 VSUB.n1226 VSUB.n125 9.3005
R1595 VSUB.n1225 VSUB.n126 9.3005
R1596 VSUB.n131 VSUB.n127 9.3005
R1597 VSUB.n1219 VSUB.n132 9.3005
R1598 VSUB.n1218 VSUB.n133 9.3005
R1599 VSUB.n1217 VSUB.n134 9.3005
R1600 VSUB.n139 VSUB.n135 9.3005
R1601 VSUB.n1211 VSUB.n140 9.3005
R1602 VSUB.n1210 VSUB.n141 9.3005
R1603 VSUB.n1209 VSUB.n142 9.3005
R1604 VSUB.n147 VSUB.n143 9.3005
R1605 VSUB.n1203 VSUB.n148 9.3005
R1606 VSUB.n1202 VSUB.n149 9.3005
R1607 VSUB.n1201 VSUB.n150 9.3005
R1608 VSUB.n163 VSUB.n151 9.3005
R1609 VSUB.n164 VSUB.n162 9.3005
R1610 VSUB.n1194 VSUB.n165 9.3005
R1611 VSUB.n1193 VSUB.n166 9.3005
R1612 VSUB.n1192 VSUB.n167 9.3005
R1613 VSUB.n1189 VSUB.n168 9.3005
R1614 VSUB.n1188 VSUB.n169 9.3005
R1615 VSUB.n1185 VSUB.n170 9.3005
R1616 VSUB.n1184 VSUB.n171 9.3005
R1617 VSUB.n1181 VSUB.n172 9.3005
R1618 VSUB.n1180 VSUB.n173 9.3005
R1619 VSUB.n1177 VSUB.n174 9.3005
R1620 VSUB.n1176 VSUB.n175 9.3005
R1621 VSUB.n183 VSUB.n176 9.3005
R1622 VSUB.n184 VSUB.n178 9.3005
R1623 VSUB.n185 VSUB.n181 9.3005
R1624 VSUB.n1168 VSUB.n1167 9.3005
R1625 VSUB.n1166 VSUB.n182 9.3005
R1626 VSUB.n1165 VSUB.n1164 9.3005
R1627 VSUB.n1163 VSUB.n186 9.3005
R1628 VSUB.n1162 VSUB.n1161 9.3005
R1629 VSUB.n1160 VSUB.n190 9.3005
R1630 VSUB.n1159 VSUB.n1158 9.3005
R1631 VSUB.n1157 VSUB.n191 9.3005
R1632 VSUB.n1156 VSUB.n1155 9.3005
R1633 VSUB.n1154 VSUB.n195 9.3005
R1634 VSUB.n1153 VSUB.n1152 9.3005
R1635 VSUB.n1151 VSUB.n196 9.3005
R1636 VSUB.n1150 VSUB.n1149 9.3005
R1637 VSUB.n1148 VSUB.n200 9.3005
R1638 VSUB.n1147 VSUB.n1146 9.3005
R1639 VSUB.n202 VSUB.n201 9.3005
R1640 VSUB.n1140 VSUB.n221 9.3005
R1641 VSUB.n1139 VSUB.n222 9.3005
R1642 VSUB.n1138 VSUB.n223 9.3005
R1643 VSUB.n229 VSUB.n224 9.3005
R1644 VSUB.n1131 VSUB.n230 9.3005
R1645 VSUB.n1130 VSUB.n231 9.3005
R1646 VSUB.n1129 VSUB.n232 9.3005
R1647 VSUB.n237 VSUB.n233 9.3005
R1648 VSUB.n1123 VSUB.n238 9.3005
R1649 VSUB.n1122 VSUB.n239 9.3005
R1650 VSUB.n1121 VSUB.n240 9.3005
R1651 VSUB.n245 VSUB.n241 9.3005
R1652 VSUB.n1115 VSUB.n246 9.3005
R1653 VSUB.n1114 VSUB.n247 9.3005
R1654 VSUB.n1113 VSUB.n248 9.3005
R1655 VSUB.n253 VSUB.n249 9.3005
R1656 VSUB.n1107 VSUB.n254 9.3005
R1657 VSUB.n1106 VSUB.n255 9.3005
R1658 VSUB.n1105 VSUB.n256 9.3005
R1659 VSUB.n261 VSUB.n257 9.3005
R1660 VSUB.n1099 VSUB.n262 9.3005
R1661 VSUB.n1098 VSUB.n263 9.3005
R1662 VSUB.n1097 VSUB.n264 9.3005
R1663 VSUB.n269 VSUB.n265 9.3005
R1664 VSUB.n1091 VSUB.n270 9.3005
R1665 VSUB.n1090 VSUB.n271 9.3005
R1666 VSUB.n1089 VSUB.n272 9.3005
R1667 VSUB.n277 VSUB.n273 9.3005
R1668 VSUB.n1083 VSUB.n278 9.3005
R1669 VSUB.n1082 VSUB.n279 9.3005
R1670 VSUB.n1081 VSUB.n280 9.3005
R1671 VSUB.n285 VSUB.n281 9.3005
R1672 VSUB.n1075 VSUB.n286 9.3005
R1673 VSUB.n1074 VSUB.n287 9.3005
R1674 VSUB.n1073 VSUB.n288 9.3005
R1675 VSUB.n293 VSUB.n289 9.3005
R1676 VSUB.n1067 VSUB.n294 9.3005
R1677 VSUB.n1066 VSUB.n295 9.3005
R1678 VSUB.n1065 VSUB.n296 9.3005
R1679 VSUB.n301 VSUB.n297 9.3005
R1680 VSUB.n1059 VSUB.n302 9.3005
R1681 VSUB.n1058 VSUB.n303 9.3005
R1682 VSUB.n1057 VSUB.n304 9.3005
R1683 VSUB.n309 VSUB.n305 9.3005
R1684 VSUB.n1051 VSUB.n310 9.3005
R1685 VSUB.n1050 VSUB.n311 9.3005
R1686 VSUB.n1049 VSUB.n312 9.3005
R1687 VSUB.n317 VSUB.n313 9.3005
R1688 VSUB.n1043 VSUB.n318 9.3005
R1689 VSUB.n1042 VSUB.n319 9.3005
R1690 VSUB.n1041 VSUB.n320 9.3005
R1691 VSUB.n325 VSUB.n321 9.3005
R1692 VSUB.n1035 VSUB.n326 9.3005
R1693 VSUB.n1034 VSUB.n327 9.3005
R1694 VSUB.n1033 VSUB.n328 9.3005
R1695 VSUB.n333 VSUB.n329 9.3005
R1696 VSUB.n1027 VSUB.n334 9.3005
R1697 VSUB.n1026 VSUB.n335 9.3005
R1698 VSUB.n1025 VSUB.n336 9.3005
R1699 VSUB.n341 VSUB.n337 9.3005
R1700 VSUB.n1019 VSUB.n342 9.3005
R1701 VSUB.n1018 VSUB.n343 9.3005
R1702 VSUB.n1017 VSUB.n344 9.3005
R1703 VSUB.n349 VSUB.n345 9.3005
R1704 VSUB.n1011 VSUB.n350 9.3005
R1705 VSUB.n1010 VSUB.n351 9.3005
R1706 VSUB.n1009 VSUB.n352 9.3005
R1707 VSUB.n357 VSUB.n353 9.3005
R1708 VSUB.n1003 VSUB.n358 9.3005
R1709 VSUB.n1002 VSUB.n359 9.3005
R1710 VSUB.n1001 VSUB.n360 9.3005
R1711 VSUB.n365 VSUB.n361 9.3005
R1712 VSUB.n995 VSUB.n366 9.3005
R1713 VSUB.n994 VSUB.n367 9.3005
R1714 VSUB.n993 VSUB.n368 9.3005
R1715 VSUB.n373 VSUB.n369 9.3005
R1716 VSUB.n987 VSUB.n374 9.3005
R1717 VSUB.n986 VSUB.n375 9.3005
R1718 VSUB.n985 VSUB.n376 9.3005
R1719 VSUB.n381 VSUB.n377 9.3005
R1720 VSUB.n979 VSUB.n382 9.3005
R1721 VSUB.n978 VSUB.n383 9.3005
R1722 VSUB.n977 VSUB.n384 9.3005
R1723 VSUB.n389 VSUB.n385 9.3005
R1724 VSUB.n971 VSUB.n390 9.3005
R1725 VSUB.n970 VSUB.n391 9.3005
R1726 VSUB.n969 VSUB.n392 9.3005
R1727 VSUB.n397 VSUB.n393 9.3005
R1728 VSUB.n963 VSUB.n398 9.3005
R1729 VSUB.n962 VSUB.n399 9.3005
R1730 VSUB.n961 VSUB.n400 9.3005
R1731 VSUB.n406 VSUB.n401 9.3005
R1732 VSUB.n955 VSUB.n407 9.3005
R1733 VSUB.n954 VSUB.n408 9.3005
R1734 VSUB.n953 VSUB.n409 9.3005
R1735 VSUB.n414 VSUB.n410 9.3005
R1736 VSUB.n947 VSUB.n415 9.3005
R1737 VSUB.n946 VSUB.n416 9.3005
R1738 VSUB.n945 VSUB.n417 9.3005
R1739 VSUB.n422 VSUB.n418 9.3005
R1740 VSUB.n939 VSUB.n423 9.3005
R1741 VSUB.n938 VSUB.n424 9.3005
R1742 VSUB.n937 VSUB.n425 9.3005
R1743 VSUB.n430 VSUB.n426 9.3005
R1744 VSUB.n931 VSUB.n431 9.3005
R1745 VSUB.n930 VSUB.n432 9.3005
R1746 VSUB.n929 VSUB.n433 9.3005
R1747 VSUB.n438 VSUB.n434 9.3005
R1748 VSUB.n923 VSUB.n439 9.3005
R1749 VSUB.n922 VSUB.n440 9.3005
R1750 VSUB.n921 VSUB.n441 9.3005
R1751 VSUB.n446 VSUB.n442 9.3005
R1752 VSUB.n915 VSUB.n447 9.3005
R1753 VSUB.n914 VSUB.n448 9.3005
R1754 VSUB.n913 VSUB.n449 9.3005
R1755 VSUB.n458 VSUB.n450 9.3005
R1756 VSUB.n906 VSUB.n459 9.3005
R1757 VSUB.n905 VSUB.n460 9.3005
R1758 VSUB.n904 VSUB.n461 9.3005
R1759 VSUB.n466 VSUB.n462 9.3005
R1760 VSUB.n898 VSUB.n467 9.3005
R1761 VSUB.n897 VSUB.n468 9.3005
R1762 VSUB.n896 VSUB.n469 9.3005
R1763 VSUB.n474 VSUB.n470 9.3005
R1764 VSUB.n890 VSUB.n475 9.3005
R1765 VSUB.n889 VSUB.n476 9.3005
R1766 VSUB.n888 VSUB.n477 9.3005
R1767 VSUB.n482 VSUB.n478 9.3005
R1768 VSUB.n882 VSUB.n483 9.3005
R1769 VSUB.n881 VSUB.n484 9.3005
R1770 VSUB.n880 VSUB.n485 9.3005
R1771 VSUB.n490 VSUB.n486 9.3005
R1772 VSUB.n874 VSUB.n491 9.3005
R1773 VSUB.n873 VSUB.n492 9.3005
R1774 VSUB.n872 VSUB.n493 9.3005
R1775 VSUB.n498 VSUB.n494 9.3005
R1776 VSUB.n866 VSUB.n499 9.3005
R1777 VSUB.n865 VSUB.n500 9.3005
R1778 VSUB.n864 VSUB.n501 9.3005
R1779 VSUB.n506 VSUB.n502 9.3005
R1780 VSUB.n857 VSUB.n507 9.3005
R1781 VSUB.n856 VSUB.n508 9.3005
R1782 VSUB.n855 VSUB.n509 9.3005
R1783 VSUB.n514 VSUB.n510 9.3005
R1784 VSUB.n849 VSUB.n515 9.3005
R1785 VSUB.n848 VSUB.n516 9.3005
R1786 VSUB.n847 VSUB.n517 9.3005
R1787 VSUB.n522 VSUB.n518 9.3005
R1788 VSUB.n841 VSUB.n523 9.3005
R1789 VSUB.n840 VSUB.n524 9.3005
R1790 VSUB.n839 VSUB.n525 9.3005
R1791 VSUB.n529 VSUB.n526 9.3005
R1792 VSUB.n833 VSUB.n530 9.3005
R1793 VSUB.n832 VSUB.n531 9.3005
R1794 VSUB.n831 VSUB.n532 9.3005
R1795 VSUB.n537 VSUB.n533 9.3005
R1796 VSUB.n825 VSUB.n538 9.3005
R1797 VSUB.n824 VSUB.n539 9.3005
R1798 VSUB.n823 VSUB.n540 9.3005
R1799 VSUB.n546 VSUB.n541 9.3005
R1800 VSUB.n817 VSUB.n547 9.3005
R1801 VSUB.n816 VSUB.n548 9.3005
R1802 VSUB.n815 VSUB.n549 9.3005
R1803 VSUB.n554 VSUB.n550 9.3005
R1804 VSUB.n809 VSUB.n555 9.3005
R1805 VSUB.n808 VSUB.n556 9.3005
R1806 VSUB.n807 VSUB.n557 9.3005
R1807 VSUB.n562 VSUB.n558 9.3005
R1808 VSUB.n801 VSUB.n563 9.3005
R1809 VSUB.n800 VSUB.n564 9.3005
R1810 VSUB.n799 VSUB.n565 9.3005
R1811 VSUB.n570 VSUB.n566 9.3005
R1812 VSUB.n793 VSUB.n571 9.3005
R1813 VSUB.n792 VSUB.n572 9.3005
R1814 VSUB.n791 VSUB.n573 9.3005
R1815 VSUB.n577 VSUB.n574 9.3005
R1816 VSUB.n785 VSUB.n578 9.3005
R1817 VSUB.n784 VSUB.n579 9.3005
R1818 VSUB.n783 VSUB.n580 9.3005
R1819 VSUB.n585 VSUB.n581 9.3005
R1820 VSUB.n777 VSUB.n586 9.3005
R1821 VSUB.n776 VSUB.n587 9.3005
R1822 VSUB.n775 VSUB.n588 9.3005
R1823 VSUB.n594 VSUB.n589 9.3005
R1824 VSUB.n769 VSUB.n595 9.3005
R1825 VSUB.n768 VSUB.n596 9.3005
R1826 VSUB.n767 VSUB.n597 9.3005
R1827 VSUB.n602 VSUB.n598 9.3005
R1828 VSUB.n761 VSUB.n603 9.3005
R1829 VSUB.n760 VSUB.n604 9.3005
R1830 VSUB.n759 VSUB.n605 9.3005
R1831 VSUB.n610 VSUB.n606 9.3005
R1832 VSUB.n753 VSUB.n611 9.3005
R1833 VSUB.n752 VSUB.n612 9.3005
R1834 VSUB.n751 VSUB.n613 9.3005
R1835 VSUB.n618 VSUB.n614 9.3005
R1836 VSUB.n745 VSUB.n619 9.3005
R1837 VSUB.n744 VSUB.n620 9.3005
R1838 VSUB.n743 VSUB.n621 9.3005
R1839 VSUB.n625 VSUB.n622 9.3005
R1840 VSUB.n737 VSUB.n626 9.3005
R1841 VSUB.n736 VSUB.n627 9.3005
R1842 VSUB.n735 VSUB.n628 9.3005
R1843 VSUB.n633 VSUB.n629 9.3005
R1844 VSUB.n729 VSUB.n634 9.3005
R1845 VSUB.n728 VSUB.n635 9.3005
R1846 VSUB.n727 VSUB.n636 9.3005
R1847 VSUB.n642 VSUB.n637 9.3005
R1848 VSUB.n721 VSUB.n643 9.3005
R1849 VSUB.n720 VSUB.n644 9.3005
R1850 VSUB.n719 VSUB.n645 9.3005
R1851 VSUB.n650 VSUB.n646 9.3005
R1852 VSUB.n713 VSUB.n651 9.3005
R1853 VSUB.n712 VSUB.n652 9.3005
R1854 VSUB.n711 VSUB.n653 9.3005
R1855 VSUB.n658 VSUB.n654 9.3005
R1856 VSUB.n705 VSUB.n659 9.3005
R1857 VSUB.n704 VSUB.n660 9.3005
R1858 VSUB.n703 VSUB.n661 9.3005
R1859 VSUB.n666 VSUB.n662 9.3005
R1860 VSUB.n697 VSUB.n667 9.3005
R1861 VSUB.n696 VSUB.n668 9.3005
R1862 VSUB.n695 VSUB.n669 9.3005
R1863 VSUB.n673 VSUB.n670 9.3005
R1864 VSUB.n689 VSUB.n674 9.3005
R1865 VSUB.n688 VSUB.n675 9.3005
R1866 VSUB.n687 VSUB.n676 9.3005
R1867 VSUB.n835 VSUB.t17 4.58097
R1868 VSUB.n543 VSUB.t14 4.58097
R1869 VSUB.n787 VSUB.t8 4.58097
R1870 VSUB.n591 VSUB.t11 4.58097
R1871 VSUB.n739 VSUB.t16 4.58097
R1872 VSUB.n639 VSUB.t9 4.58097
R1873 VSUB.n691 VSUB.t13 4.58097
R1874 VSUB.n106 VSUB.n21 4.29189
R1875 VSUB.n681 VSUB.n677 4.29189
R1876 VSUB.n106 VSUB.n105 2.59416
R1877 VSUB.n681 VSUB.n676 2.59416
R1878 VSUB VSUB.n1246 0.371506
R1879 VSUB.n105 VSUB.n22 0.078625
R1880 VSUB.n23 VSUB.n22 0.078625
R1881 VSUB.n24 VSUB.n23 0.078625
R1882 VSUB.n25 VSUB.n24 0.078625
R1883 VSUB.n26 VSUB.n25 0.078625
R1884 VSUB.n27 VSUB.n26 0.078625
R1885 VSUB.n28 VSUB.n27 0.078625
R1886 VSUB.n29 VSUB.n28 0.078625
R1887 VSUB.n30 VSUB.n29 0.078625
R1888 VSUB.n31 VSUB.n30 0.078625
R1889 VSUB.n32 VSUB.n31 0.078625
R1890 VSUB.n33 VSUB.n32 0.078625
R1891 VSUB.n34 VSUB.n33 0.078625
R1892 VSUB.n35 VSUB.n34 0.078625
R1893 VSUB.n36 VSUB.n35 0.078625
R1894 VSUB.n37 VSUB.n36 0.078625
R1895 VSUB.n38 VSUB.n37 0.078625
R1896 VSUB.n39 VSUB.n38 0.078625
R1897 VSUB.n40 VSUB.n39 0.078625
R1898 VSUB.n41 VSUB.n40 0.078625
R1899 VSUB.n42 VSUB.n41 0.078625
R1900 VSUB.n43 VSUB.n42 0.078625
R1901 VSUB.n44 VSUB.n43 0.078625
R1902 VSUB.n45 VSUB.n44 0.078625
R1903 VSUB.n46 VSUB.n45 0.078625
R1904 VSUB.n47 VSUB.n46 0.078625
R1905 VSUB.n48 VSUB.n47 0.078625
R1906 VSUB.n48 VSUB.n0 0.078625
R1907 VSUB.n1244 VSUB.n1 0.078625
R1908 VSUB.n111 VSUB.n1 0.078625
R1909 VSUB.n112 VSUB.n111 0.078625
R1910 VSUB.n113 VSUB.n112 0.078625
R1911 VSUB.n114 VSUB.n113 0.078625
R1912 VSUB.n122 VSUB.n114 0.078625
R1913 VSUB.n123 VSUB.n122 0.078625
R1914 VSUB.n124 VSUB.n123 0.078625
R1915 VSUB.n125 VSUB.n124 0.078625
R1916 VSUB.n126 VSUB.n125 0.078625
R1917 VSUB.n131 VSUB.n126 0.078625
R1918 VSUB.n132 VSUB.n131 0.078625
R1919 VSUB.n133 VSUB.n132 0.078625
R1920 VSUB.n134 VSUB.n133 0.078625
R1921 VSUB.n139 VSUB.n134 0.078625
R1922 VSUB.n140 VSUB.n139 0.078625
R1923 VSUB.n141 VSUB.n140 0.078625
R1924 VSUB.n142 VSUB.n141 0.078625
R1925 VSUB.n147 VSUB.n142 0.078625
R1926 VSUB.n148 VSUB.n147 0.078625
R1927 VSUB.n149 VSUB.n148 0.078625
R1928 VSUB.n150 VSUB.n149 0.078625
R1929 VSUB.n163 VSUB.n150 0.078625
R1930 VSUB.n164 VSUB.n163 0.078625
R1931 VSUB.n165 VSUB.n164 0.078625
R1932 VSUB.n166 VSUB.n165 0.078625
R1933 VSUB.n167 VSUB.n166 0.078625
R1934 VSUB.n168 VSUB.n167 0.078625
R1935 VSUB.n169 VSUB.n168 0.078625
R1936 VSUB.n170 VSUB.n169 0.078625
R1937 VSUB.n171 VSUB.n170 0.078625
R1938 VSUB.n172 VSUB.n171 0.078625
R1939 VSUB.n173 VSUB.n172 0.078625
R1940 VSUB.n174 VSUB.n173 0.078625
R1941 VSUB.n175 VSUB.n174 0.078625
R1942 VSUB.n183 VSUB.n175 0.078625
R1943 VSUB.n184 VSUB.n183 0.078625
R1944 VSUB.n185 VSUB.n184 0.078625
R1945 VSUB.n1167 VSUB.n185 0.078625
R1946 VSUB.n1167 VSUB.n1166 0.078625
R1947 VSUB.n1166 VSUB.n1165 0.078625
R1948 VSUB.n1165 VSUB.n186 0.078625
R1949 VSUB.n1161 VSUB.n186 0.078625
R1950 VSUB.n1161 VSUB.n1160 0.078625
R1951 VSUB.n1160 VSUB.n1159 0.078625
R1952 VSUB.n1159 VSUB.n191 0.078625
R1953 VSUB.n1155 VSUB.n191 0.078625
R1954 VSUB.n1155 VSUB.n1154 0.078625
R1955 VSUB.n1154 VSUB.n1153 0.078625
R1956 VSUB.n1153 VSUB.n196 0.078625
R1957 VSUB.n1149 VSUB.n196 0.078625
R1958 VSUB.n1149 VSUB.n1148 0.078625
R1959 VSUB.n1148 VSUB.n1147 0.078625
R1960 VSUB.n1147 VSUB.n201 0.078625
R1961 VSUB.n221 VSUB.n201 0.078625
R1962 VSUB.n222 VSUB.n221 0.078625
R1963 VSUB.n223 VSUB.n222 0.078625
R1964 VSUB.n229 VSUB.n223 0.078625
R1965 VSUB.n230 VSUB.n229 0.078625
R1966 VSUB.n231 VSUB.n230 0.078625
R1967 VSUB.n232 VSUB.n231 0.078625
R1968 VSUB.n237 VSUB.n232 0.078625
R1969 VSUB.n238 VSUB.n237 0.078625
R1970 VSUB.n239 VSUB.n238 0.078625
R1971 VSUB.n240 VSUB.n239 0.078625
R1972 VSUB.n245 VSUB.n240 0.078625
R1973 VSUB.n246 VSUB.n245 0.078625
R1974 VSUB.n247 VSUB.n246 0.078625
R1975 VSUB.n248 VSUB.n247 0.078625
R1976 VSUB.n253 VSUB.n248 0.078625
R1977 VSUB.n254 VSUB.n253 0.078625
R1978 VSUB.n255 VSUB.n254 0.078625
R1979 VSUB.n256 VSUB.n255 0.078625
R1980 VSUB.n261 VSUB.n256 0.078625
R1981 VSUB.n262 VSUB.n261 0.078625
R1982 VSUB.n263 VSUB.n262 0.078625
R1983 VSUB.n264 VSUB.n263 0.078625
R1984 VSUB.n269 VSUB.n264 0.078625
R1985 VSUB.n270 VSUB.n269 0.078625
R1986 VSUB.n271 VSUB.n270 0.078625
R1987 VSUB.n272 VSUB.n271 0.078625
R1988 VSUB.n277 VSUB.n272 0.078625
R1989 VSUB.n278 VSUB.n277 0.078625
R1990 VSUB.n279 VSUB.n278 0.078625
R1991 VSUB.n280 VSUB.n279 0.078625
R1992 VSUB.n285 VSUB.n280 0.078625
R1993 VSUB.n286 VSUB.n285 0.078625
R1994 VSUB.n287 VSUB.n286 0.078625
R1995 VSUB.n288 VSUB.n287 0.078625
R1996 VSUB.n293 VSUB.n288 0.078625
R1997 VSUB.n294 VSUB.n293 0.078625
R1998 VSUB.n295 VSUB.n294 0.078625
R1999 VSUB.n296 VSUB.n295 0.078625
R2000 VSUB.n301 VSUB.n296 0.078625
R2001 VSUB.n302 VSUB.n301 0.078625
R2002 VSUB.n303 VSUB.n302 0.078625
R2003 VSUB.n304 VSUB.n303 0.078625
R2004 VSUB.n309 VSUB.n304 0.078625
R2005 VSUB.n310 VSUB.n309 0.078625
R2006 VSUB.n311 VSUB.n310 0.078625
R2007 VSUB.n312 VSUB.n311 0.078625
R2008 VSUB.n317 VSUB.n312 0.078625
R2009 VSUB.n318 VSUB.n317 0.078625
R2010 VSUB.n319 VSUB.n318 0.078625
R2011 VSUB.n320 VSUB.n319 0.078625
R2012 VSUB.n325 VSUB.n320 0.078625
R2013 VSUB.n326 VSUB.n325 0.078625
R2014 VSUB.n327 VSUB.n326 0.078625
R2015 VSUB.n328 VSUB.n327 0.078625
R2016 VSUB.n333 VSUB.n328 0.078625
R2017 VSUB.n334 VSUB.n333 0.078625
R2018 VSUB.n335 VSUB.n334 0.078625
R2019 VSUB.n336 VSUB.n335 0.078625
R2020 VSUB.n341 VSUB.n336 0.078625
R2021 VSUB.n342 VSUB.n341 0.078625
R2022 VSUB.n343 VSUB.n342 0.078625
R2023 VSUB.n344 VSUB.n343 0.078625
R2024 VSUB.n349 VSUB.n344 0.078625
R2025 VSUB.n350 VSUB.n349 0.078625
R2026 VSUB.n351 VSUB.n350 0.078625
R2027 VSUB.n352 VSUB.n351 0.078625
R2028 VSUB.n357 VSUB.n352 0.078625
R2029 VSUB.n358 VSUB.n357 0.078625
R2030 VSUB.n359 VSUB.n358 0.078625
R2031 VSUB.n360 VSUB.n359 0.078625
R2032 VSUB.n365 VSUB.n360 0.078625
R2033 VSUB.n366 VSUB.n365 0.078625
R2034 VSUB.n367 VSUB.n366 0.078625
R2035 VSUB.n368 VSUB.n367 0.078625
R2036 VSUB.n373 VSUB.n368 0.078625
R2037 VSUB.n374 VSUB.n373 0.078625
R2038 VSUB.n375 VSUB.n374 0.078625
R2039 VSUB.n376 VSUB.n375 0.078625
R2040 VSUB.n381 VSUB.n376 0.078625
R2041 VSUB.n382 VSUB.n381 0.078625
R2042 VSUB.n383 VSUB.n382 0.078625
R2043 VSUB.n384 VSUB.n383 0.078625
R2044 VSUB.n389 VSUB.n384 0.078625
R2045 VSUB.n390 VSUB.n389 0.078625
R2046 VSUB.n391 VSUB.n390 0.078625
R2047 VSUB.n392 VSUB.n391 0.078625
R2048 VSUB.n397 VSUB.n392 0.078625
R2049 VSUB.n398 VSUB.n397 0.078625
R2050 VSUB.n399 VSUB.n398 0.078625
R2051 VSUB.n400 VSUB.n399 0.078625
R2052 VSUB.n406 VSUB.n400 0.078625
R2053 VSUB.n407 VSUB.n406 0.078625
R2054 VSUB.n408 VSUB.n407 0.078625
R2055 VSUB.n409 VSUB.n408 0.078625
R2056 VSUB.n414 VSUB.n409 0.078625
R2057 VSUB.n415 VSUB.n414 0.078625
R2058 VSUB.n416 VSUB.n415 0.078625
R2059 VSUB.n417 VSUB.n416 0.078625
R2060 VSUB.n422 VSUB.n417 0.078625
R2061 VSUB.n423 VSUB.n422 0.078625
R2062 VSUB.n424 VSUB.n423 0.078625
R2063 VSUB.n425 VSUB.n424 0.078625
R2064 VSUB.n430 VSUB.n425 0.078625
R2065 VSUB.n431 VSUB.n430 0.078625
R2066 VSUB.n432 VSUB.n431 0.078625
R2067 VSUB.n433 VSUB.n432 0.078625
R2068 VSUB.n438 VSUB.n433 0.078625
R2069 VSUB.n439 VSUB.n438 0.078625
R2070 VSUB.n440 VSUB.n439 0.078625
R2071 VSUB.n441 VSUB.n440 0.078625
R2072 VSUB.n446 VSUB.n441 0.078625
R2073 VSUB.n447 VSUB.n446 0.078625
R2074 VSUB.n448 VSUB.n447 0.078625
R2075 VSUB.n449 VSUB.n448 0.078625
R2076 VSUB.n458 VSUB.n449 0.078625
R2077 VSUB.n459 VSUB.n458 0.078625
R2078 VSUB.n460 VSUB.n459 0.078625
R2079 VSUB.n461 VSUB.n460 0.078625
R2080 VSUB.n466 VSUB.n461 0.078625
R2081 VSUB.n467 VSUB.n466 0.078625
R2082 VSUB.n468 VSUB.n467 0.078625
R2083 VSUB.n469 VSUB.n468 0.078625
R2084 VSUB.n474 VSUB.n469 0.078625
R2085 VSUB.n475 VSUB.n474 0.078625
R2086 VSUB.n476 VSUB.n475 0.078625
R2087 VSUB.n477 VSUB.n476 0.078625
R2088 VSUB.n482 VSUB.n477 0.078625
R2089 VSUB.n483 VSUB.n482 0.078625
R2090 VSUB.n484 VSUB.n483 0.078625
R2091 VSUB.n485 VSUB.n484 0.078625
R2092 VSUB.n490 VSUB.n485 0.078625
R2093 VSUB.n491 VSUB.n490 0.078625
R2094 VSUB.n492 VSUB.n491 0.078625
R2095 VSUB.n493 VSUB.n492 0.078625
R2096 VSUB.n498 VSUB.n493 0.078625
R2097 VSUB.n499 VSUB.n498 0.078625
R2098 VSUB.n500 VSUB.n499 0.078625
R2099 VSUB.n501 VSUB.n500 0.078625
R2100 VSUB.n506 VSUB.n501 0.078625
R2101 VSUB.n507 VSUB.n506 0.078625
R2102 VSUB.n508 VSUB.n507 0.078625
R2103 VSUB.n509 VSUB.n508 0.078625
R2104 VSUB.n514 VSUB.n509 0.078625
R2105 VSUB.n515 VSUB.n514 0.078625
R2106 VSUB.n516 VSUB.n515 0.078625
R2107 VSUB.n517 VSUB.n516 0.078625
R2108 VSUB.n522 VSUB.n517 0.078625
R2109 VSUB.n523 VSUB.n522 0.078625
R2110 VSUB.n524 VSUB.n523 0.078625
R2111 VSUB.n525 VSUB.n524 0.078625
R2112 VSUB.n529 VSUB.n525 0.078625
R2113 VSUB.n530 VSUB.n529 0.078625
R2114 VSUB.n531 VSUB.n530 0.078625
R2115 VSUB.n532 VSUB.n531 0.078625
R2116 VSUB.n537 VSUB.n532 0.078625
R2117 VSUB.n538 VSUB.n537 0.078625
R2118 VSUB.n539 VSUB.n538 0.078625
R2119 VSUB.n540 VSUB.n539 0.078625
R2120 VSUB.n546 VSUB.n540 0.078625
R2121 VSUB.n547 VSUB.n546 0.078625
R2122 VSUB.n548 VSUB.n547 0.078625
R2123 VSUB.n549 VSUB.n548 0.078625
R2124 VSUB.n554 VSUB.n549 0.078625
R2125 VSUB.n555 VSUB.n554 0.078625
R2126 VSUB.n556 VSUB.n555 0.078625
R2127 VSUB.n557 VSUB.n556 0.078625
R2128 VSUB.n562 VSUB.n557 0.078625
R2129 VSUB.n563 VSUB.n562 0.078625
R2130 VSUB.n564 VSUB.n563 0.078625
R2131 VSUB.n565 VSUB.n564 0.078625
R2132 VSUB.n570 VSUB.n565 0.078625
R2133 VSUB.n571 VSUB.n570 0.078625
R2134 VSUB.n572 VSUB.n571 0.078625
R2135 VSUB.n573 VSUB.n572 0.078625
R2136 VSUB.n577 VSUB.n573 0.078625
R2137 VSUB.n578 VSUB.n577 0.078625
R2138 VSUB.n579 VSUB.n578 0.078625
R2139 VSUB.n580 VSUB.n579 0.078625
R2140 VSUB.n585 VSUB.n580 0.078625
R2141 VSUB.n586 VSUB.n585 0.078625
R2142 VSUB.n587 VSUB.n586 0.078625
R2143 VSUB.n588 VSUB.n587 0.078625
R2144 VSUB.n594 VSUB.n588 0.078625
R2145 VSUB.n595 VSUB.n594 0.078625
R2146 VSUB.n596 VSUB.n595 0.078625
R2147 VSUB.n597 VSUB.n596 0.078625
R2148 VSUB.n602 VSUB.n597 0.078625
R2149 VSUB.n603 VSUB.n602 0.078625
R2150 VSUB.n604 VSUB.n603 0.078625
R2151 VSUB.n605 VSUB.n604 0.078625
R2152 VSUB.n610 VSUB.n605 0.078625
R2153 VSUB.n611 VSUB.n610 0.078625
R2154 VSUB.n612 VSUB.n611 0.078625
R2155 VSUB.n613 VSUB.n612 0.078625
R2156 VSUB.n618 VSUB.n613 0.078625
R2157 VSUB.n619 VSUB.n618 0.078625
R2158 VSUB.n620 VSUB.n619 0.078625
R2159 VSUB.n621 VSUB.n620 0.078625
R2160 VSUB.n625 VSUB.n621 0.078625
R2161 VSUB.n626 VSUB.n625 0.078625
R2162 VSUB.n627 VSUB.n626 0.078625
R2163 VSUB.n628 VSUB.n627 0.078625
R2164 VSUB.n633 VSUB.n628 0.078625
R2165 VSUB.n634 VSUB.n633 0.078625
R2166 VSUB.n635 VSUB.n634 0.078625
R2167 VSUB.n636 VSUB.n635 0.078625
R2168 VSUB.n642 VSUB.n636 0.078625
R2169 VSUB.n643 VSUB.n642 0.078625
R2170 VSUB.n644 VSUB.n643 0.078625
R2171 VSUB.n645 VSUB.n644 0.078625
R2172 VSUB.n650 VSUB.n645 0.078625
R2173 VSUB.n651 VSUB.n650 0.078625
R2174 VSUB.n652 VSUB.n651 0.078625
R2175 VSUB.n653 VSUB.n652 0.078625
R2176 VSUB.n658 VSUB.n653 0.078625
R2177 VSUB.n659 VSUB.n658 0.078625
R2178 VSUB.n660 VSUB.n659 0.078625
R2179 VSUB.n661 VSUB.n660 0.078625
R2180 VSUB.n666 VSUB.n661 0.078625
R2181 VSUB.n667 VSUB.n666 0.078625
R2182 VSUB.n668 VSUB.n667 0.078625
R2183 VSUB.n669 VSUB.n668 0.078625
R2184 VSUB.n673 VSUB.n669 0.078625
R2185 VSUB.n674 VSUB.n673 0.078625
R2186 VSUB.n675 VSUB.n674 0.078625
R2187 VSUB.n676 VSUB.n675 0.078625
R2188 VSUB.n1245 VSUB.n0 0.0708125
R2189 VSUB.n1245 VSUB.n1244 0.0083125
R2190 nsl3 nsl3.t2 106.469
R2191 nsl3 nsl3.n0 1.32394
R2192 nsl3.n0 nsl3.t0 110.918
R2193 nsl3.n0 nsl3.t1 227.636
R2194 nsl2 nsl2.t2 106.094
R2195 nsl2 nsl2.n0 1.32394
R2196 nsl2.n0 nsl2.t0 110.543
R2197 nsl2.n0 nsl2.t1 227.494
R2198 nsl1 nsl1.t1 105.719
R2199 nsl1 nsl1.n0 1.32394
R2200 nsl1.n0 nsl1.t2 110.168
R2201 nsl1.n0 nsl1.t0 227.353
R2202 ne2.t0 ne2.n0 948
R2203 ne2.n2 ne2.t3 20.773
R2204 ne2.n1 ne2.t0 20.773
R2205 ne2.n1 ne2.t2 18.8695
R2206 ne2.n2 ne2.t1 18.8695
R2207 ne2 ne2.n3 7.4785
R2208 ne2.n3 ne2.n2 4.7639
R2209 ne2.n3 ne2.n1 3.93357
R2210 a_8525_348.t0 a_8525_348.t1 34.9493
R2211 a_8045_1858.t0 a_8045_1858.t1 34.9493
R2212 a_7565_348.t0 a_7565_348.t1 34.9493
R2213 a_7085_1858.t0 a_7085_1858.t1 34.9493
R2214 a_6605_348.t0 a_6605_348.t1 34.9493
R2215 a_6125_1858.t0 a_6125_1858.t1 34.9493
R2216 a_5645_348.t0 a_5645_348.t1 34.9493
R2217 a_5165_1858.t0 a_5165_1858.t1 34.9493
R2218 a_4685_348.t0 a_4685_348.t1 34.9493
R2219 a_4205_1858.t0 a_4205_1858.t1 34.9493
R2220 a_3725_348.t0 a_3725_348.t1 34.9493
R2221 a_3245_1858.t0 a_3245_1858.t1 34.9493
R2222 a_2765_348.t0 a_2765_348.t1 34.9493
R2223 a_2285_1858.t0 a_2285_1858.t1 34.9493
R2224 a_1805_348.t0 a_1805_348.t1 34.9493
R2225 a_1325_1858.t0 a_1325_1858.t1 34.9493
R2226 a_845_348.t0 a_845_348.t1 34.9493
R2227 a_365_1858.t0 a_365_1858.t1 34.9493
R2228 a_8525_2648.t0 a_8525_2648.t1 34.9493
R2229 a_8045_4158.t0 a_8045_4158.t1 34.9493
R2230 a_7565_2648.t0 a_7565_2648.t1 34.9493
R2231 a_7085_4158.t0 a_7085_4158.t1 34.9493
R2232 a_6605_2648.t0 a_6605_2648.t1 34.9493
R2233 a_6125_4158.t0 a_6125_4158.t1 34.9493
R2234 a_5645_2648.t0 a_5645_2648.t1 34.9493
R2235 a_5165_4158.t0 a_5165_4158.t1 34.9493
R2236 a_4685_2648.t0 a_4685_2648.t1 34.9493
R2237 a_4205_4158.t0 a_4205_4158.t1 34.9493
R2238 a_3725_2648.t0 a_3725_2648.t1 34.9493
R2239 a_3245_4158.t0 a_3245_4158.t1 34.9493
R2240 a_2765_2648.t0 a_2765_2648.t1 34.9493
R2241 a_2285_4158.t0 a_2285_4158.t1 34.9493
R2242 a_1805_2648.t0 a_1805_2648.t1 34.9493
R2243 a_1325_4158.t0 a_1325_4158.t1 34.9493
R2244 a_845_2648.t0 a_845_2648.t1 34.9493
R2245 a_365_2648.t0 a_365_2648.t1 57.869
R2246 a_365_4158.t0 a_365_4158.t1 34.9493
R2247 a_8525_6458.t0 a_8525_6458.t1 34.9493
R2248 nd055.n0 nd055.t1 29.3947
R2249 nd055.n0 nd055.t0 29.3195
R2250 nd055 nd055.n0 7.9861
R2251 a_7565_6458.t0 a_7565_6458.t1 34.9493
R2252 a_7085_4948.t0 a_7085_4948.t1 34.9493
R2253 a_6605_6458.t0 a_6605_6458.t1 34.9493
R2254 a_6125_4948.t0 a_6125_4948.t1 34.9493
R2255 a_5645_6458.t0 a_5645_6458.t1 34.9493
R2256 vcasc.n0 vcasc.t0 30.0421
R2257 vcasc.n0 vcasc.t1 29.1456
R2258 vcasc vcasc.n0 7.8169
R2259 a_4685_4948.t0 a_4685_4948.t1 34.9493
R2260 a_4205_6458.t0 a_4205_6458.t1 34.9493
R2261 a_3725_4948.t0 a_3725_4948.t1 34.9493
R2262 a_3245_6458.t0 a_3245_6458.t1 34.9493
R2263 a_2765_4948.t0 a_2765_4948.t1 34.9493
R2264 a_2285_6458.t0 a_2285_6458.t1 34.9493
R2265 nd12.n0 nd12.t1 228.582
R2266 nd12.n0 nd12.t2 113.567
R2267 nd12.n1 nd12.t3 29.0469
R2268 nd12.n1 nd12.t0 28.8213
R2269 nd12 nd12.n2 7.6477
R2270 nd12.n2 nd12.n1 7.4641
R2271 nd12.n2 nd12.n0 1.17221
R2272 a_1325_6458.t0 a_1325_6458.t1 34.9493
R2273 a_845_4948.t0 a_845_4948.t1 34.9493
R2274 a_365_4948.t0 a_365_4948.t1 57.869
R2275 a_365_6458.t0 a_365_6458.t1 34.9493
R2276 a_3725_7248.t0 a_3725_7248.t1 34.9493
R2277 a_3245_8758.t0 a_3245_8758.t1 34.9493
R2278 a_2765_7248.t0 a_2765_7248.t1 34.9493
R2279 a_2285_8758.t0 a_2285_8758.t1 34.9493
R2280 a_1805_7248.t0 a_1805_7248.t1 34.9493
R2281 a_1325_8758.t0 a_1325_8758.t1 34.9493
R2282 a_845_7248.t0 a_845_7248.t1 34.9493
R2283 a_365_7248.t0 a_365_7248.t1 60.2534
R2284 a_365_8758.t0 a_365_8758.t1 34.9493
R2285 vdd.n386 vdd.n266 385.067
R2286 vdd.n569 vdd.n449 385.067
R2287 vdd.n121 vdd.n120 349.265
R2288 vdd.n160 vdd.n159 349.265
R2289 vdd.n199 vdd.n198 349.265
R2290 vdd.n228 vdd.n225 245.593
R2291 vdd.n74 vdd.n71 245.593
R2292 vdd.n414 vdd.n413 239.639
R2293 vdd.n597 vdd.n596 239.639
R2294 vdd.n383 vdd.n382 235.792
R2295 vdd.n515 vdd.n465 235.792
R2296 vdd.n201 vdd.n200 188.611
R2297 vdd.n164 vdd.n37 188.611
R2298 vdd.n197 vdd.n196 188.611
R2299 vdd.n119 vdd.n118 188.611
R2300 vdd.n158 vdd.n157 188.611
R2301 vdd.n123 vdd.n122 188.611
R2302 vdd.n266 vdd.n265 185
R2303 vdd.n384 vdd.n266 185
R2304 vdd.n387 vdd.n386 185
R2305 vdd.n386 vdd.n385 185
R2306 vdd.n263 vdd.n262 185
R2307 vdd.n262 vdd.n261 185
R2308 vdd.n392 vdd.n391 185
R2309 vdd.n393 vdd.n392 185
R2310 vdd.n260 vdd.n259 185
R2311 vdd.n394 vdd.n260 185
R2312 vdd.n398 vdd.n397 185
R2313 vdd.n397 vdd.n396 185
R2314 vdd.n257 vdd.n256 185
R2315 vdd.n395 vdd.n256 185
R2316 vdd.n403 vdd.n402 185
R2317 vdd.n403 vdd.n255 185
R2318 vdd.n404 vdd.n246 185
R2319 vdd.n405 vdd.n404 185
R2320 vdd.n423 vdd.n247 185
R2321 vdd.n406 vdd.n247 185
R2322 vdd.n422 vdd.n248 185
R2323 vdd.n407 vdd.n248 185
R2324 vdd.n421 vdd.n249 185
R2325 vdd.n408 vdd.n249 185
R2326 vdd.n409 vdd.n250 185
R2327 vdd.n410 vdd.n409 185
R2328 vdd.n417 vdd.n252 185
R2329 vdd.n411 vdd.n252 185
R2330 vdd.n416 vdd.n253 185
R2331 vdd.n412 vdd.n253 185
R2332 vdd.n415 vdd.n254 185
R2333 vdd.n301 vdd.n300 185
R2334 vdd.n306 vdd.n305 185
R2335 vdd.n308 vdd.n307 185
R2336 vdd.n311 vdd.n310 185
R2337 vdd.n309 vdd.n298 185
R2338 vdd.n316 vdd.n315 185
R2339 vdd.n318 vdd.n317 185
R2340 vdd.n321 vdd.n320 185
R2341 vdd.n319 vdd.n296 185
R2342 vdd.n326 vdd.n325 185
R2343 vdd.n328 vdd.n327 185
R2344 vdd.n331 vdd.n330 185
R2345 vdd.n329 vdd.n294 185
R2346 vdd.n336 vdd.n335 185
R2347 vdd.n338 vdd.n337 185
R2348 vdd.n341 vdd.n340 185
R2349 vdd.n339 vdd.n292 185
R2350 vdd.n346 vdd.n345 185
R2351 vdd.n348 vdd.n347 185
R2352 vdd.n351 vdd.n350 185
R2353 vdd.n349 vdd.n290 185
R2354 vdd.n356 vdd.n355 185
R2355 vdd.n358 vdd.n357 185
R2356 vdd.n361 vdd.n360 185
R2357 vdd.n359 vdd.n288 185
R2358 vdd.n366 vdd.n365 185
R2359 vdd.n368 vdd.n367 185
R2360 vdd.n371 vdd.n370 185
R2361 vdd.n369 vdd.n286 185
R2362 vdd.n376 vdd.n375 185
R2363 vdd.n378 vdd.n377 185
R2364 vdd.n380 vdd.n379 185
R2365 vdd.n284 vdd.n283 185
R2366 vdd.n598 vdd.n437 185
R2367 vdd.n599 vdd.n436 185
R2368 vdd.n595 vdd.n436 185
R2369 vdd.n600 vdd.n435 185
R2370 vdd.n594 vdd.n435 185
R2371 vdd.n592 vdd.n433 185
R2372 vdd.n593 vdd.n592 185
R2373 vdd.n604 vdd.n432 185
R2374 vdd.n591 vdd.n432 185
R2375 vdd.n605 vdd.n431 185
R2376 vdd.n590 vdd.n431 185
R2377 vdd.n606 vdd.n430 185
R2378 vdd.n589 vdd.n430 185
R2379 vdd.n587 vdd.n429 185
R2380 vdd.n588 vdd.n587 185
R2381 vdd.n586 vdd.n585 185
R2382 vdd.n586 vdd.n438 185
R2383 vdd.n440 vdd.n439 185
R2384 vdd.n578 vdd.n439 185
R2385 vdd.n581 vdd.n580 185
R2386 vdd.n580 vdd.n579 185
R2387 vdd.n443 vdd.n442 185
R2388 vdd.n577 vdd.n443 185
R2389 vdd.n575 vdd.n574 185
R2390 vdd.n576 vdd.n575 185
R2391 vdd.n446 vdd.n445 185
R2392 vdd.n445 vdd.n444 185
R2393 vdd.n570 vdd.n569 185
R2394 vdd.n569 vdd.n568 185
R2395 vdd.n449 vdd.n448 185
R2396 vdd.n565 vdd.n564 185
R2397 vdd.n467 vdd.n466 185
R2398 vdd.n567 vdd.n466 185
R2399 vdd.n560 vdd.n470 185
R2400 vdd.n559 vdd.n471 185
R2401 vdd.n558 vdd.n472 185
R2402 vdd.n475 vdd.n473 185
R2403 vdd.n554 vdd.n476 185
R2404 vdd.n553 vdd.n477 185
R2405 vdd.n552 vdd.n478 185
R2406 vdd.n481 vdd.n479 185
R2407 vdd.n548 vdd.n482 185
R2408 vdd.n547 vdd.n483 185
R2409 vdd.n546 vdd.n484 185
R2410 vdd.n487 vdd.n485 185
R2411 vdd.n542 vdd.n488 185
R2412 vdd.n541 vdd.n489 185
R2413 vdd.n540 vdd.n490 185
R2414 vdd.n493 vdd.n491 185
R2415 vdd.n536 vdd.n494 185
R2416 vdd.n535 vdd.n495 185
R2417 vdd.n534 vdd.n496 185
R2418 vdd.n499 vdd.n497 185
R2419 vdd.n530 vdd.n500 185
R2420 vdd.n529 vdd.n501 185
R2421 vdd.n528 vdd.n502 185
R2422 vdd.n505 vdd.n503 185
R2423 vdd.n524 vdd.n506 185
R2424 vdd.n523 vdd.n507 185
R2425 vdd.n522 vdd.n508 185
R2426 vdd.n511 vdd.n509 185
R2427 vdd.n518 vdd.n512 185
R2428 vdd.n517 vdd.n513 185
R2429 vdd.n516 vdd.n514 185
R2430 vdd.n159 vdd.n158 185
R2431 vdd.n40 vdd.n39 185
R2432 vdd.n39 vdd.n38 185
R2433 vdd.n155 vdd.n154 185
R2434 vdd.n154 vdd.n153 185
R2435 vdd.n43 vdd.n42 185
R2436 vdd.n152 vdd.n43 185
R2437 vdd.n150 vdd.n149 185
R2438 vdd.n151 vdd.n150 185
R2439 vdd.n46 vdd.n45 185
R2440 vdd.n45 vdd.n44 185
R2441 vdd.n145 vdd.n144 185
R2442 vdd.n144 vdd.n143 185
R2443 vdd.n49 vdd.n48 185
R2444 vdd.n142 vdd.n49 185
R2445 vdd.n140 vdd.n139 185
R2446 vdd.n141 vdd.n140 185
R2447 vdd.n52 vdd.n51 185
R2448 vdd.n51 vdd.n50 185
R2449 vdd.n109 vdd.n106 185
R2450 vdd.n106 vdd.n105 185
R2451 vdd.n111 vdd.n110 185
R2452 vdd.n112 vdd.n111 185
R2453 vdd.n104 vdd.n103 185
R2454 vdd.n113 vdd.n104 185
R2455 vdd.n116 vdd.n115 185
R2456 vdd.n115 vdd.n114 185
R2457 vdd.n101 vdd.n100 185
R2458 vdd.n100 vdd.n99 185
R2459 vdd.n120 vdd.n119 185
R2460 vdd.n198 vdd.n197 185
R2461 vdd.n18 vdd.n17 185
R2462 vdd.n17 vdd.n16 185
R2463 vdd.n194 vdd.n193 185
R2464 vdd.n193 vdd.n192 185
R2465 vdd.n21 vdd.n20 185
R2466 vdd.n191 vdd.n21 185
R2467 vdd.n189 vdd.n188 185
R2468 vdd.n190 vdd.n189 185
R2469 vdd.n24 vdd.n23 185
R2470 vdd.n23 vdd.n22 185
R2471 vdd.n184 vdd.n183 185
R2472 vdd.n183 vdd.n182 185
R2473 vdd.n27 vdd.n26 185
R2474 vdd.n181 vdd.n27 185
R2475 vdd.n179 vdd.n178 185
R2476 vdd.n180 vdd.n179 185
R2477 vdd.n30 vdd.n29 185
R2478 vdd.n29 vdd.n28 185
R2479 vdd.n173 vdd.n172 185
R2480 vdd.n172 vdd.n171 185
R2481 vdd.n33 vdd.n32 185
R2482 vdd.n170 vdd.n33 185
R2483 vdd.n168 vdd.n167 185
R2484 vdd.n169 vdd.n168 185
R2485 vdd.n36 vdd.n35 185
R2486 vdd.n35 vdd.n34 185
R2487 vdd.n163 vdd.n162 185
R2488 vdd.n162 vdd.n161 185
R2489 vdd.n160 vdd.n37 185
R2490 vdd.n227 vdd.n226 185
R2491 vdd.n223 vdd.n222 185
R2492 vdd.n229 vdd.n223 185
R2493 vdd.n232 vdd.n231 185
R2494 vdd.n231 vdd.n230 185
R2495 vdd.n233 vdd.n218 185
R2496 vdd.n218 vdd.n217 185
R2497 vdd.n235 vdd.n234 185
R2498 vdd.n236 vdd.n235 185
R2499 vdd.n6 vdd.n4 185
R2500 vdd.n237 vdd.n6 185
R2501 vdd.n240 vdd.n239 185
R2502 vdd.n239 vdd.n238 185
R2503 vdd.n5 vdd.n3 185
R2504 vdd.n216 vdd.n5 185
R2505 vdd.n214 vdd.n213 185
R2506 vdd.n215 vdd.n214 185
R2507 vdd.n9 vdd.n8 185
R2508 vdd.n8 vdd.n7 185
R2509 vdd.n209 vdd.n208 185
R2510 vdd.n208 vdd.n207 185
R2511 vdd.n12 vdd.n11 185
R2512 vdd.n206 vdd.n12 185
R2513 vdd.n204 vdd.n203 185
R2514 vdd.n205 vdd.n204 185
R2515 vdd.n15 vdd.n14 185
R2516 vdd.n14 vdd.n13 185
R2517 vdd.n200 vdd.n199 185
R2518 vdd.n122 vdd.n121 185
R2519 vdd.n124 vdd.n64 185
R2520 vdd.n98 vdd.n64 185
R2521 vdd.n125 vdd.n63 185
R2522 vdd.n97 vdd.n63 185
R2523 vdd.n126 vdd.n62 185
R2524 vdd.n96 vdd.n62 185
R2525 vdd.n94 vdd.n60 185
R2526 vdd.n95 vdd.n94 185
R2527 vdd.n130 vdd.n59 185
R2528 vdd.n93 vdd.n59 185
R2529 vdd.n131 vdd.n58 185
R2530 vdd.n92 vdd.n58 185
R2531 vdd.n132 vdd.n57 185
R2532 vdd.n91 vdd.n57 185
R2533 vdd.n89 vdd.n56 185
R2534 vdd.n90 vdd.n89 185
R2535 vdd.n88 vdd.n87 185
R2536 vdd.n88 vdd.n65 185
R2537 vdd.n67 vdd.n66 185
R2538 vdd.n80 vdd.n66 185
R2539 vdd.n83 vdd.n82 185
R2540 vdd.n82 vdd.n81 185
R2541 vdd.n70 vdd.n69 185
R2542 vdd.n79 vdd.n70 185
R2543 vdd.n77 vdd.n76 185
R2544 vdd.n78 vdd.n77 185
R2545 vdd.n73 vdd.n72 185
R2546 vdd.n78 vdd.n71 153.077
R2547 vdd.n229 vdd.n228 153.077
R2548 vdd.n386 vdd.n262 126.668
R2549 vdd.n392 vdd.n262 126.668
R2550 vdd.n392 vdd.n260 126.668
R2551 vdd.n397 vdd.n260 126.668
R2552 vdd.n397 vdd.n256 126.668
R2553 vdd.n403 vdd.n256 126.668
R2554 vdd.n404 vdd.n403 126.668
R2555 vdd.n404 vdd.n247 126.668
R2556 vdd.n248 vdd.n247 126.668
R2557 vdd.n249 vdd.n248 126.668
R2558 vdd.n409 vdd.n249 126.668
R2559 vdd.n409 vdd.n252 126.668
R2560 vdd.n253 vdd.n252 126.668
R2561 vdd.n254 vdd.n253 126.668
R2562 vdd.n300 vdd.n266 126.668
R2563 vdd.n307 vdd.n306 126.668
R2564 vdd.n310 vdd.n309 126.668
R2565 vdd.n317 vdd.n316 126.668
R2566 vdd.n320 vdd.n319 126.668
R2567 vdd.n327 vdd.n326 126.668
R2568 vdd.n330 vdd.n329 126.668
R2569 vdd.n337 vdd.n336 126.668
R2570 vdd.n340 vdd.n339 126.668
R2571 vdd.n347 vdd.n346 126.668
R2572 vdd.n350 vdd.n349 126.668
R2573 vdd.n357 vdd.n356 126.668
R2574 vdd.n360 vdd.n359 126.668
R2575 vdd.n367 vdd.n366 126.668
R2576 vdd.n370 vdd.n369 126.668
R2577 vdd.n377 vdd.n376 126.668
R2578 vdd.n379 vdd.n283 126.668
R2579 vdd.n565 vdd.n466 126.668
R2580 vdd.n470 vdd.n466 126.668
R2581 vdd.n472 vdd.n471 126.668
R2582 vdd.n476 vdd.n475 126.668
R2583 vdd.n478 vdd.n477 126.668
R2584 vdd.n482 vdd.n481 126.668
R2585 vdd.n484 vdd.n483 126.668
R2586 vdd.n488 vdd.n487 126.668
R2587 vdd.n490 vdd.n489 126.668
R2588 vdd.n494 vdd.n493 126.668
R2589 vdd.n496 vdd.n495 126.668
R2590 vdd.n500 vdd.n499 126.668
R2591 vdd.n502 vdd.n501 126.668
R2592 vdd.n506 vdd.n505 126.668
R2593 vdd.n508 vdd.n507 126.668
R2594 vdd.n512 vdd.n511 126.668
R2595 vdd.n514 vdd.n513 126.668
R2596 vdd.n569 vdd.n445 126.668
R2597 vdd.n575 vdd.n445 126.668
R2598 vdd.n575 vdd.n443 126.668
R2599 vdd.n580 vdd.n443 126.668
R2600 vdd.n580 vdd.n439 126.668
R2601 vdd.n586 vdd.n439 126.668
R2602 vdd.n587 vdd.n586 126.668
R2603 vdd.n587 vdd.n430 126.668
R2604 vdd.n431 vdd.n430 126.668
R2605 vdd.n432 vdd.n431 126.668
R2606 vdd.n592 vdd.n432 126.668
R2607 vdd.n592 vdd.n435 126.668
R2608 vdd.n436 vdd.n435 126.668
R2609 vdd.n437 vdd.n436 126.668
R2610 vdd.n200 vdd.n14 126.668
R2611 vdd.n204 vdd.n14 126.668
R2612 vdd.n204 vdd.n12 126.668
R2613 vdd.n208 vdd.n12 126.668
R2614 vdd.n208 vdd.n8 126.668
R2615 vdd.n214 vdd.n8 126.668
R2616 vdd.n214 vdd.n5 126.668
R2617 vdd.n239 vdd.n5 126.668
R2618 vdd.n239 vdd.n6 126.668
R2619 vdd.n235 vdd.n6 126.668
R2620 vdd.n235 vdd.n218 126.668
R2621 vdd.n231 vdd.n218 126.668
R2622 vdd.n231 vdd.n223 126.668
R2623 vdd.n227 vdd.n223 126.668
R2624 vdd.n162 vdd.n37 126.668
R2625 vdd.n162 vdd.n35 126.668
R2626 vdd.n168 vdd.n35 126.668
R2627 vdd.n168 vdd.n33 126.668
R2628 vdd.n172 vdd.n33 126.668
R2629 vdd.n172 vdd.n29 126.668
R2630 vdd.n179 vdd.n29 126.668
R2631 vdd.n179 vdd.n27 126.668
R2632 vdd.n183 vdd.n27 126.668
R2633 vdd.n183 vdd.n23 126.668
R2634 vdd.n189 vdd.n23 126.668
R2635 vdd.n189 vdd.n21 126.668
R2636 vdd.n193 vdd.n21 126.668
R2637 vdd.n193 vdd.n17 126.668
R2638 vdd.n197 vdd.n17 126.668
R2639 vdd.n119 vdd.n100 126.668
R2640 vdd.n115 vdd.n100 126.668
R2641 vdd.n115 vdd.n104 126.668
R2642 vdd.n111 vdd.n104 126.668
R2643 vdd.n111 vdd.n106 126.668
R2644 vdd.n106 vdd.n51 126.668
R2645 vdd.n140 vdd.n51 126.668
R2646 vdd.n140 vdd.n49 126.668
R2647 vdd.n144 vdd.n49 126.668
R2648 vdd.n144 vdd.n45 126.668
R2649 vdd.n150 vdd.n45 126.668
R2650 vdd.n150 vdd.n43 126.668
R2651 vdd.n154 vdd.n43 126.668
R2652 vdd.n154 vdd.n39 126.668
R2653 vdd.n158 vdd.n39 126.668
R2654 vdd.n77 vdd.n72 126.668
R2655 vdd.n77 vdd.n70 126.668
R2656 vdd.n82 vdd.n70 126.668
R2657 vdd.n82 vdd.n66 126.668
R2658 vdd.n88 vdd.n66 126.668
R2659 vdd.n89 vdd.n88 126.668
R2660 vdd.n89 vdd.n57 126.668
R2661 vdd.n58 vdd.n57 126.668
R2662 vdd.n59 vdd.n58 126.668
R2663 vdd.n94 vdd.n59 126.668
R2664 vdd.n94 vdd.n62 126.668
R2665 vdd.n63 vdd.n62 126.668
R2666 vdd.n64 vdd.n63 126.668
R2667 vdd.n122 vdd.n64 126.668
R2668 vdd.n413 vdd.n412 99.7961
R2669 vdd.n596 vdd.n595 99.7961
R2670 vdd.n385 vdd.n384 75.5457
R2671 vdd.n568 vdd.n567 75.5457
R2672 vdd.n79 vdd.n78 69.8534
R2673 vdd.n81 vdd.n79 69.8534
R2674 vdd.n81 vdd.n80 69.8534
R2675 vdd.n80 vdd.n65 69.8534
R2676 vdd.n90 vdd.n65 69.8534
R2677 vdd.n92 vdd.n91 69.8534
R2678 vdd.n93 vdd.n92 69.8534
R2679 vdd.n95 vdd.n93 69.8534
R2680 vdd.n96 vdd.n95 69.8534
R2681 vdd.n97 vdd.n96 69.8534
R2682 vdd.n98 vdd.n97 69.8534
R2683 vdd.n121 vdd.n98 69.8534
R2684 vdd.n120 vdd.n99 69.8534
R2685 vdd.n114 vdd.n99 69.8534
R2686 vdd.n114 vdd.n113 69.8534
R2687 vdd.n113 vdd.n112 69.8534
R2688 vdd.n112 vdd.n105 69.8534
R2689 vdd.n105 vdd.n50 69.8534
R2690 vdd.n141 vdd.n50 69.8534
R2691 vdd.n143 vdd.n142 69.8534
R2692 vdd.n143 vdd.n44 69.8534
R2693 vdd.n151 vdd.n44 69.8534
R2694 vdd.n152 vdd.n151 69.8534
R2695 vdd.n153 vdd.n152 69.8534
R2696 vdd.n153 vdd.n38 69.8534
R2697 vdd.n159 vdd.n38 69.8534
R2698 vdd.n161 vdd.n160 69.8534
R2699 vdd.n161 vdd.n34 69.8534
R2700 vdd.n169 vdd.n34 69.8534
R2701 vdd.n170 vdd.n169 69.8534
R2702 vdd.n171 vdd.n170 69.8534
R2703 vdd.n171 vdd.n28 69.8534
R2704 vdd.n180 vdd.n28 69.8534
R2705 vdd.n182 vdd.n181 69.8534
R2706 vdd.n182 vdd.n22 69.8534
R2707 vdd.n190 vdd.n22 69.8534
R2708 vdd.n191 vdd.n190 69.8534
R2709 vdd.n192 vdd.n191 69.8534
R2710 vdd.n192 vdd.n16 69.8534
R2711 vdd.n198 vdd.n16 69.8534
R2712 vdd.n199 vdd.n13 69.8534
R2713 vdd.n205 vdd.n13 69.8534
R2714 vdd.n206 vdd.n205 69.8534
R2715 vdd.n207 vdd.n206 69.8534
R2716 vdd.n207 vdd.n7 69.8534
R2717 vdd.n215 vdd.n7 69.8534
R2718 vdd.n216 vdd.n215 69.8534
R2719 vdd.n238 vdd.n237 69.8534
R2720 vdd.n237 vdd.n236 69.8534
R2721 vdd.n236 vdd.n217 69.8534
R2722 vdd.n230 vdd.n217 69.8534
R2723 vdd.n230 vdd.n229 69.8534
R2724 vdd.n384 vdd.n267 68.9104
R2725 vdd.n384 vdd.n268 68.9104
R2726 vdd.n384 vdd.n269 68.9104
R2727 vdd.n384 vdd.n270 68.9104
R2728 vdd.n384 vdd.n271 68.9104
R2729 vdd.n384 vdd.n272 68.9104
R2730 vdd.n384 vdd.n273 68.9104
R2731 vdd.n384 vdd.n274 68.9104
R2732 vdd.n384 vdd.n275 68.9104
R2733 vdd.n384 vdd.n276 68.9104
R2734 vdd.n384 vdd.n277 68.9104
R2735 vdd.n384 vdd.n278 68.9104
R2736 vdd.n384 vdd.n279 68.9104
R2737 vdd.n384 vdd.n280 68.9104
R2738 vdd.n384 vdd.n281 68.9104
R2739 vdd.n384 vdd.n282 68.9104
R2740 vdd.n384 vdd.n383 68.9104
R2741 vdd.n567 vdd.n566 68.9104
R2742 vdd.n567 vdd.n450 68.9104
R2743 vdd.n567 vdd.n451 68.9104
R2744 vdd.n567 vdd.n452 68.9104
R2745 vdd.n567 vdd.n453 68.9104
R2746 vdd.n567 vdd.n454 68.9104
R2747 vdd.n567 vdd.n455 68.9104
R2748 vdd.n567 vdd.n456 68.9104
R2749 vdd.n567 vdd.n457 68.9104
R2750 vdd.n567 vdd.n458 68.9104
R2751 vdd.n567 vdd.n459 68.9104
R2752 vdd.n567 vdd.n460 68.9104
R2753 vdd.n567 vdd.n461 68.9104
R2754 vdd.n567 vdd.n462 68.9104
R2755 vdd.n567 vdd.n463 68.9104
R2756 vdd.n567 vdd.n464 68.9104
R2757 vdd.n567 vdd.n465 68.9104
R2758 vdd.n300 vdd.n267 47.1822
R2759 vdd.n307 vdd.n268 47.1822
R2760 vdd.n309 vdd.n269 47.1822
R2761 vdd.n317 vdd.n270 47.1822
R2762 vdd.n319 vdd.n271 47.1822
R2763 vdd.n327 vdd.n272 47.1822
R2764 vdd.n329 vdd.n273 47.1822
R2765 vdd.n337 vdd.n274 47.1822
R2766 vdd.n339 vdd.n275 47.1822
R2767 vdd.n347 vdd.n276 47.1822
R2768 vdd.n349 vdd.n277 47.1822
R2769 vdd.n357 vdd.n278 47.1822
R2770 vdd.n359 vdd.n279 47.1822
R2771 vdd.n367 vdd.n280 47.1822
R2772 vdd.n369 vdd.n281 47.1822
R2773 vdd.n377 vdd.n282 47.1822
R2774 vdd.n383 vdd.n283 47.1822
R2775 vdd.n306 vdd.n267 47.1822
R2776 vdd.n310 vdd.n268 47.1822
R2777 vdd.n316 vdd.n269 47.1822
R2778 vdd.n320 vdd.n270 47.1822
R2779 vdd.n326 vdd.n271 47.1822
R2780 vdd.n330 vdd.n272 47.1822
R2781 vdd.n336 vdd.n273 47.1822
R2782 vdd.n340 vdd.n274 47.1822
R2783 vdd.n346 vdd.n275 47.1822
R2784 vdd.n350 vdd.n276 47.1822
R2785 vdd.n356 vdd.n277 47.1822
R2786 vdd.n360 vdd.n278 47.1822
R2787 vdd.n366 vdd.n279 47.1822
R2788 vdd.n370 vdd.n280 47.1822
R2789 vdd.n376 vdd.n281 47.1822
R2790 vdd.n379 vdd.n282 47.1822
R2791 vdd.n566 vdd.n449 47.1822
R2792 vdd.n470 vdd.n450 47.1822
R2793 vdd.n472 vdd.n451 47.1822
R2794 vdd.n476 vdd.n452 47.1822
R2795 vdd.n478 vdd.n453 47.1822
R2796 vdd.n482 vdd.n454 47.1822
R2797 vdd.n484 vdd.n455 47.1822
R2798 vdd.n488 vdd.n456 47.1822
R2799 vdd.n490 vdd.n457 47.1822
R2800 vdd.n494 vdd.n458 47.1822
R2801 vdd.n496 vdd.n459 47.1822
R2802 vdd.n500 vdd.n460 47.1822
R2803 vdd.n502 vdd.n461 47.1822
R2804 vdd.n506 vdd.n462 47.1822
R2805 vdd.n508 vdd.n463 47.1822
R2806 vdd.n512 vdd.n464 47.1822
R2807 vdd.n514 vdd.n465 47.1822
R2808 vdd.n566 vdd.n565 47.1822
R2809 vdd.n471 vdd.n450 47.1822
R2810 vdd.n475 vdd.n451 47.1822
R2811 vdd.n477 vdd.n452 47.1822
R2812 vdd.n481 vdd.n453 47.1822
R2813 vdd.n483 vdd.n454 47.1822
R2814 vdd.n487 vdd.n455 47.1822
R2815 vdd.n489 vdd.n456 47.1822
R2816 vdd.n493 vdd.n457 47.1822
R2817 vdd.n495 vdd.n458 47.1822
R2818 vdd.n499 vdd.n459 47.1822
R2819 vdd.n501 vdd.n460 47.1822
R2820 vdd.n505 vdd.n461 47.1822
R2821 vdd.n507 vdd.n462 47.1822
R2822 vdd.n511 vdd.n463 47.1822
R2823 vdd.n513 vdd.n464 47.1822
R2824 vdd.n413 vdd.n254 44.8982
R2825 vdd.n596 vdd.n437 44.8982
R2826 vdd.n228 vdd.n227 41.3647
R2827 vdd.n72 vdd.n71 41.3647
R2828 vdd.t0 vdd.n90 34.927
R2829 vdd.n91 vdd.t0 34.927
R2830 vdd.t4 vdd.n141 34.927
R2831 vdd.n142 vdd.t4 34.927
R2832 vdd.t5 vdd.n180 34.927
R2833 vdd.n181 vdd.t5 34.927
R2834 vdd.t3 vdd.n216 34.927
R2835 vdd.n238 vdd.t3 34.927
R2836 vdd.n387 vdd.n265 34.7932
R2837 vdd.n570 vdd.n448 34.7932
R2838 vdd.n426 vdd.t2 34.6387
R2839 vdd.n385 vdd.n261 25.2665
R2840 vdd.n393 vdd.n261 25.2665
R2841 vdd.n394 vdd.n393 25.2665
R2842 vdd.n396 vdd.n394 25.2665
R2843 vdd.n396 vdd.n395 25.2665
R2844 vdd.n395 vdd.n255 25.2665
R2845 vdd.n405 vdd.n255 25.2665
R2846 vdd.n407 vdd.n406 25.2665
R2847 vdd.n408 vdd.n407 25.2665
R2848 vdd.n410 vdd.n408 25.2665
R2849 vdd.n411 vdd.n410 25.2665
R2850 vdd.n412 vdd.n411 25.2665
R2851 vdd.n568 vdd.n444 25.2665
R2852 vdd.n576 vdd.n444 25.2665
R2853 vdd.n577 vdd.n576 25.2665
R2854 vdd.n579 vdd.n577 25.2665
R2855 vdd.n579 vdd.n578 25.2665
R2856 vdd.n578 vdd.n438 25.2665
R2857 vdd.n588 vdd.n438 25.2665
R2858 vdd.n590 vdd.n589 25.2665
R2859 vdd.n591 vdd.n590 25.2665
R2860 vdd.n593 vdd.n591 25.2665
R2861 vdd.n594 vdd.n593 25.2665
R2862 vdd.n595 vdd.n594 25.2665
R2863 vdd.n264 vdd.t7 25.2161
R2864 vdd.n447 vdd.t9 25.2161
R2865 vdd.n243 vdd.n242 13.0935
R2866 vdd.n176 vdd.n0 13.0935
R2867 vdd.n137 vdd.n136 13.0935
R2868 vdd.n135 vdd.n134 13.0935
R2869 vdd.t6 vdd.n405 12.6335
R2870 vdd.n406 vdd.t6 12.6335
R2871 vdd.t8 vdd.n588 12.6335
R2872 vdd.n589 vdd.t8 12.6335
R2873 vdd.n426 vdd.n425 12.3885
R2874 vdd.n609 vdd.n608 12.3885
R2875 vdd.n387 vdd.n263 11.6369
R2876 vdd.n391 vdd.n263 11.6369
R2877 vdd.n391 vdd.n259 11.6369
R2878 vdd.n398 vdd.n259 11.6369
R2879 vdd.n398 vdd.n257 11.6369
R2880 vdd.n402 vdd.n257 11.6369
R2881 vdd.n402 vdd.n246 11.6369
R2882 vdd.n423 vdd.n246 11.6369
R2883 vdd.n423 vdd.n422 11.6369
R2884 vdd.n422 vdd.n421 11.6369
R2885 vdd.n421 vdd.n250 11.6369
R2886 vdd.n417 vdd.n250 11.6369
R2887 vdd.n417 vdd.n416 11.6369
R2888 vdd.n416 vdd.n415 11.6369
R2889 vdd.n305 vdd.n301 11.6369
R2890 vdd.n308 vdd.n305 11.6369
R2891 vdd.n311 vdd.n308 11.6369
R2892 vdd.n311 vdd.n298 11.6369
R2893 vdd.n315 vdd.n298 11.6369
R2894 vdd.n318 vdd.n315 11.6369
R2895 vdd.n321 vdd.n318 11.6369
R2896 vdd.n321 vdd.n296 11.6369
R2897 vdd.n325 vdd.n296 11.6369
R2898 vdd.n328 vdd.n325 11.6369
R2899 vdd.n331 vdd.n328 11.6369
R2900 vdd.n331 vdd.n294 11.6369
R2901 vdd.n335 vdd.n294 11.6369
R2902 vdd.n338 vdd.n335 11.6369
R2903 vdd.n341 vdd.n338 11.6369
R2904 vdd.n341 vdd.n292 11.6369
R2905 vdd.n345 vdd.n292 11.6369
R2906 vdd.n348 vdd.n345 11.6369
R2907 vdd.n351 vdd.n348 11.6369
R2908 vdd.n351 vdd.n290 11.6369
R2909 vdd.n355 vdd.n290 11.6369
R2910 vdd.n358 vdd.n355 11.6369
R2911 vdd.n361 vdd.n358 11.6369
R2912 vdd.n361 vdd.n288 11.6369
R2913 vdd.n365 vdd.n288 11.6369
R2914 vdd.n368 vdd.n365 11.6369
R2915 vdd.n371 vdd.n368 11.6369
R2916 vdd.n371 vdd.n286 11.6369
R2917 vdd.n375 vdd.n286 11.6369
R2918 vdd.n378 vdd.n375 11.6369
R2919 vdd.n380 vdd.n378 11.6369
R2920 vdd.n380 vdd.n284 11.6369
R2921 vdd.n570 vdd.n446 11.6369
R2922 vdd.n574 vdd.n446 11.6369
R2923 vdd.n574 vdd.n442 11.6369
R2924 vdd.n581 vdd.n442 11.6369
R2925 vdd.n581 vdd.n440 11.6369
R2926 vdd.n585 vdd.n440 11.6369
R2927 vdd.n585 vdd.n429 11.6369
R2928 vdd.n606 vdd.n429 11.6369
R2929 vdd.n606 vdd.n605 11.6369
R2930 vdd.n605 vdd.n604 11.6369
R2931 vdd.n604 vdd.n433 11.6369
R2932 vdd.n600 vdd.n433 11.6369
R2933 vdd.n600 vdd.n599 11.6369
R2934 vdd.n599 vdd.n598 11.6369
R2935 vdd.n564 vdd.n467 11.6369
R2936 vdd.n560 vdd.n467 11.6369
R2937 vdd.n560 vdd.n559 11.6369
R2938 vdd.n559 vdd.n558 11.6369
R2939 vdd.n558 vdd.n473 11.6369
R2940 vdd.n554 vdd.n473 11.6369
R2941 vdd.n554 vdd.n553 11.6369
R2942 vdd.n553 vdd.n552 11.6369
R2943 vdd.n552 vdd.n479 11.6369
R2944 vdd.n548 vdd.n479 11.6369
R2945 vdd.n548 vdd.n547 11.6369
R2946 vdd.n547 vdd.n546 11.6369
R2947 vdd.n546 vdd.n485 11.6369
R2948 vdd.n542 vdd.n485 11.6369
R2949 vdd.n542 vdd.n541 11.6369
R2950 vdd.n541 vdd.n540 11.6369
R2951 vdd.n540 vdd.n491 11.6369
R2952 vdd.n536 vdd.n491 11.6369
R2953 vdd.n536 vdd.n535 11.6369
R2954 vdd.n535 vdd.n534 11.6369
R2955 vdd.n534 vdd.n497 11.6369
R2956 vdd.n530 vdd.n497 11.6369
R2957 vdd.n530 vdd.n529 11.6369
R2958 vdd.n529 vdd.n528 11.6369
R2959 vdd.n528 vdd.n503 11.6369
R2960 vdd.n524 vdd.n503 11.6369
R2961 vdd.n524 vdd.n523 11.6369
R2962 vdd.n523 vdd.n522 11.6369
R2963 vdd.n522 vdd.n509 11.6369
R2964 vdd.n518 vdd.n509 11.6369
R2965 vdd.n518 vdd.n517 11.6369
R2966 vdd.n517 vdd.n516 11.6369
R2967 vdd.n203 vdd.n15 11.6369
R2968 vdd.n203 vdd.n11 11.6369
R2969 vdd.n209 vdd.n11 11.6369
R2970 vdd.n209 vdd.n9 11.6369
R2971 vdd.n213 vdd.n9 11.6369
R2972 vdd.n213 vdd.n3 11.6369
R2973 vdd.n240 vdd.n3 11.6369
R2974 vdd.n240 vdd.n4 11.6369
R2975 vdd.n234 vdd.n4 11.6369
R2976 vdd.n234 vdd.n233 11.6369
R2977 vdd.n233 vdd.n232 11.6369
R2978 vdd.n232 vdd.n222 11.6369
R2979 vdd.n226 vdd.n222 11.6369
R2980 vdd.n163 vdd.n36 11.6369
R2981 vdd.n167 vdd.n36 11.6369
R2982 vdd.n167 vdd.n32 11.6369
R2983 vdd.n173 vdd.n32 11.6369
R2984 vdd.n173 vdd.n30 11.6369
R2985 vdd.n178 vdd.n30 11.6369
R2986 vdd.n178 vdd.n26 11.6369
R2987 vdd.n184 vdd.n26 11.6369
R2988 vdd.n184 vdd.n24 11.6369
R2989 vdd.n188 vdd.n24 11.6369
R2990 vdd.n188 vdd.n20 11.6369
R2991 vdd.n194 vdd.n20 11.6369
R2992 vdd.n194 vdd.n18 11.6369
R2993 vdd.n116 vdd.n101 11.6369
R2994 vdd.n116 vdd.n103 11.6369
R2995 vdd.n110 vdd.n103 11.6369
R2996 vdd.n110 vdd.n109 11.6369
R2997 vdd.n109 vdd.n52 11.6369
R2998 vdd.n139 vdd.n52 11.6369
R2999 vdd.n139 vdd.n48 11.6369
R3000 vdd.n145 vdd.n48 11.6369
R3001 vdd.n145 vdd.n46 11.6369
R3002 vdd.n149 vdd.n46 11.6369
R3003 vdd.n149 vdd.n42 11.6369
R3004 vdd.n155 vdd.n42 11.6369
R3005 vdd.n155 vdd.n40 11.6369
R3006 vdd.n76 vdd.n73 11.6369
R3007 vdd.n76 vdd.n69 11.6369
R3008 vdd.n83 vdd.n69 11.6369
R3009 vdd.n83 vdd.n67 11.6369
R3010 vdd.n87 vdd.n67 11.6369
R3011 vdd.n87 vdd.n56 11.6369
R3012 vdd.n132 vdd.n56 11.6369
R3013 vdd.n132 vdd.n131 11.6369
R3014 vdd.n131 vdd.n130 11.6369
R3015 vdd.n130 vdd.n60 11.6369
R3016 vdd.n126 vdd.n60 11.6369
R3017 vdd.n126 vdd.n125 11.6369
R3018 vdd.n125 vdd.n124 11.6369
R3019 vdd.n301 vdd.n265 11.055
R3020 vdd.n564 vdd.n448 11.055
R3021 vdd.n303 vdd.n301 9.3005
R3022 vdd.n305 vdd.n304 9.3005
R3023 vdd.n308 vdd.n299 9.3005
R3024 vdd.n312 vdd.n311 9.3005
R3025 vdd.n313 vdd.n298 9.3005
R3026 vdd.n315 vdd.n314 9.3005
R3027 vdd.n318 vdd.n297 9.3005
R3028 vdd.n322 vdd.n321 9.3005
R3029 vdd.n323 vdd.n296 9.3005
R3030 vdd.n325 vdd.n324 9.3005
R3031 vdd.n328 vdd.n295 9.3005
R3032 vdd.n332 vdd.n331 9.3005
R3033 vdd.n333 vdd.n294 9.3005
R3034 vdd.n335 vdd.n334 9.3005
R3035 vdd.n338 vdd.n293 9.3005
R3036 vdd.n342 vdd.n341 9.3005
R3037 vdd.n343 vdd.n292 9.3005
R3038 vdd.n345 vdd.n344 9.3005
R3039 vdd.n348 vdd.n291 9.3005
R3040 vdd.n352 vdd.n351 9.3005
R3041 vdd.n353 vdd.n290 9.3005
R3042 vdd.n355 vdd.n354 9.3005
R3043 vdd.n358 vdd.n289 9.3005
R3044 vdd.n362 vdd.n361 9.3005
R3045 vdd.n363 vdd.n288 9.3005
R3046 vdd.n365 vdd.n364 9.3005
R3047 vdd.n368 vdd.n287 9.3005
R3048 vdd.n372 vdd.n371 9.3005
R3049 vdd.n373 vdd.n286 9.3005
R3050 vdd.n375 vdd.n374 9.3005
R3051 vdd.n378 vdd.n285 9.3005
R3052 vdd.n381 vdd.n380 9.3005
R3053 vdd.n302 vdd.n265 9.3005
R3054 vdd.n388 vdd.n387 9.3005
R3055 vdd.n389 vdd.n263 9.3005
R3056 vdd.n391 vdd.n390 9.3005
R3057 vdd.n259 vdd.n258 9.3005
R3058 vdd.n399 vdd.n398 9.3005
R3059 vdd.n400 vdd.n257 9.3005
R3060 vdd.n402 vdd.n401 9.3005
R3061 vdd.n246 vdd.n244 9.3005
R3062 vdd.n424 vdd.n423 9.3005
R3063 vdd.n422 vdd.n245 9.3005
R3064 vdd.n421 vdd.n420 9.3005
R3065 vdd.n419 vdd.n250 9.3005
R3066 vdd.n418 vdd.n417 9.3005
R3067 vdd.n416 vdd.n251 9.3005
R3068 vdd.n517 vdd.n510 9.3005
R3069 vdd.n519 vdd.n518 9.3005
R3070 vdd.n520 vdd.n509 9.3005
R3071 vdd.n522 vdd.n521 9.3005
R3072 vdd.n523 vdd.n504 9.3005
R3073 vdd.n525 vdd.n524 9.3005
R3074 vdd.n526 vdd.n503 9.3005
R3075 vdd.n528 vdd.n527 9.3005
R3076 vdd.n529 vdd.n498 9.3005
R3077 vdd.n531 vdd.n530 9.3005
R3078 vdd.n532 vdd.n497 9.3005
R3079 vdd.n534 vdd.n533 9.3005
R3080 vdd.n535 vdd.n492 9.3005
R3081 vdd.n537 vdd.n536 9.3005
R3082 vdd.n538 vdd.n491 9.3005
R3083 vdd.n540 vdd.n539 9.3005
R3084 vdd.n541 vdd.n486 9.3005
R3085 vdd.n543 vdd.n542 9.3005
R3086 vdd.n544 vdd.n485 9.3005
R3087 vdd.n546 vdd.n545 9.3005
R3088 vdd.n547 vdd.n480 9.3005
R3089 vdd.n549 vdd.n548 9.3005
R3090 vdd.n550 vdd.n479 9.3005
R3091 vdd.n552 vdd.n551 9.3005
R3092 vdd.n553 vdd.n474 9.3005
R3093 vdd.n555 vdd.n554 9.3005
R3094 vdd.n556 vdd.n473 9.3005
R3095 vdd.n558 vdd.n557 9.3005
R3096 vdd.n559 vdd.n469 9.3005
R3097 vdd.n561 vdd.n560 9.3005
R3098 vdd.n562 vdd.n467 9.3005
R3099 vdd.n564 vdd.n563 9.3005
R3100 vdd.n468 vdd.n448 9.3005
R3101 vdd.n571 vdd.n570 9.3005
R3102 vdd.n572 vdd.n446 9.3005
R3103 vdd.n574 vdd.n573 9.3005
R3104 vdd.n442 vdd.n441 9.3005
R3105 vdd.n582 vdd.n581 9.3005
R3106 vdd.n583 vdd.n440 9.3005
R3107 vdd.n585 vdd.n584 9.3005
R3108 vdd.n429 vdd.n427 9.3005
R3109 vdd.n607 vdd.n606 9.3005
R3110 vdd.n605 vdd.n428 9.3005
R3111 vdd.n604 vdd.n603 9.3005
R3112 vdd.n602 vdd.n433 9.3005
R3113 vdd.n601 vdd.n600 9.3005
R3114 vdd.n599 vdd.n434 9.3005
R3115 vdd.n203 vdd.n202 9.3005
R3116 vdd.n11 vdd.n10 9.3005
R3117 vdd.n210 vdd.n209 9.3005
R3118 vdd.n211 vdd.n9 9.3005
R3119 vdd.n213 vdd.n212 9.3005
R3120 vdd.n3 vdd.n1 9.3005
R3121 vdd.n241 vdd.n240 9.3005
R3122 vdd.n4 vdd.n2 9.3005
R3123 vdd.n234 vdd.n219 9.3005
R3124 vdd.n233 vdd.n220 9.3005
R3125 vdd.n232 vdd.n221 9.3005
R3126 vdd.n224 vdd.n222 9.3005
R3127 vdd.n165 vdd.n36 9.3005
R3128 vdd.n167 vdd.n166 9.3005
R3129 vdd.n32 vdd.n31 9.3005
R3130 vdd.n174 vdd.n173 9.3005
R3131 vdd.n175 vdd.n30 9.3005
R3132 vdd.n178 vdd.n177 9.3005
R3133 vdd.n26 vdd.n25 9.3005
R3134 vdd.n185 vdd.n184 9.3005
R3135 vdd.n186 vdd.n24 9.3005
R3136 vdd.n188 vdd.n187 9.3005
R3137 vdd.n20 vdd.n19 9.3005
R3138 vdd.n195 vdd.n194 9.3005
R3139 vdd.n117 vdd.n116 9.3005
R3140 vdd.n103 vdd.n102 9.3005
R3141 vdd.n110 vdd.n107 9.3005
R3142 vdd.n109 vdd.n108 9.3005
R3143 vdd.n53 vdd.n52 9.3005
R3144 vdd.n139 vdd.n138 9.3005
R3145 vdd.n48 vdd.n47 9.3005
R3146 vdd.n146 vdd.n145 9.3005
R3147 vdd.n147 vdd.n46 9.3005
R3148 vdd.n149 vdd.n148 9.3005
R3149 vdd.n42 vdd.n41 9.3005
R3150 vdd.n156 vdd.n155 9.3005
R3151 vdd.n76 vdd.n75 9.3005
R3152 vdd.n69 vdd.n68 9.3005
R3153 vdd.n84 vdd.n83 9.3005
R3154 vdd.n85 vdd.n67 9.3005
R3155 vdd.n87 vdd.n86 9.3005
R3156 vdd.n56 vdd.n54 9.3005
R3157 vdd.n133 vdd.n132 9.3005
R3158 vdd.n131 vdd.n55 9.3005
R3159 vdd.n130 vdd.n129 9.3005
R3160 vdd.n128 vdd.n60 9.3005
R3161 vdd.n127 vdd.n126 9.3005
R3162 vdd.n125 vdd.n61 9.3005
R3163 vdd.n135 vdd.t1 6.90713
R3164 vdd.n382 vdd.n284 3.56667
R3165 vdd.n415 vdd.n414 3.56667
R3166 vdd.n516 vdd.n515 3.56667
R3167 vdd.n598 vdd.n597 3.56667
R3168 vdd.n201 vdd.n15 3.56667
R3169 vdd.n226 vdd.n225 3.56667
R3170 vdd.n164 vdd.n163 3.56667
R3171 vdd.n196 vdd.n18 3.56667
R3172 vdd.n118 vdd.n101 3.56667
R3173 vdd.n157 vdd.n40 3.56667
R3174 vdd.n74 vdd.n73 3.56667
R3175 vdd.n124 vdd.n123 3.56667
R3176 vdd.n382 vdd.n381 2.99921
R3177 vdd.n414 vdd.n251 2.99921
R3178 vdd.n515 vdd.n510 2.99921
R3179 vdd.n597 vdd.n434 2.99921
R3180 vdd.n202 vdd.n201 2.99921
R3181 vdd.n225 vdd.n224 2.99921
R3182 vdd.n165 vdd.n164 2.99921
R3183 vdd.n196 vdd.n195 2.99921
R3184 vdd.n118 vdd.n117 2.99921
R3185 vdd.n157 vdd.n156 2.99921
R3186 vdd.n75 vdd.n74 2.99921
R3187 vdd.n123 vdd.n61 2.99921
R3188 vdd.n609 vdd.n426 0.76425
R3189 vdd vdd.n609 0.593875
R3190 vdd.n136 vdd.n135 0.588
R3191 vdd.n136 vdd.n0 0.588
R3192 vdd.n243 vdd.n0 0.588
R3193 vdd.n302 vdd.n264 0.207318
R3194 vdd.n468 vdd.n447 0.207318
R3195 vdd vdd.n243 0.165
R3196 vdd.n388 vdd.n264 0.133455
R3197 vdd.n571 vdd.n447 0.133455
R3198 vdd.n304 vdd.n303 0.114136
R3199 vdd.n304 vdd.n299 0.114136
R3200 vdd.n312 vdd.n299 0.114136
R3201 vdd.n313 vdd.n312 0.114136
R3202 vdd.n314 vdd.n313 0.114136
R3203 vdd.n314 vdd.n297 0.114136
R3204 vdd.n322 vdd.n297 0.114136
R3205 vdd.n323 vdd.n322 0.114136
R3206 vdd.n324 vdd.n323 0.114136
R3207 vdd.n324 vdd.n295 0.114136
R3208 vdd.n332 vdd.n295 0.114136
R3209 vdd.n333 vdd.n332 0.114136
R3210 vdd.n334 vdd.n333 0.114136
R3211 vdd.n334 vdd.n293 0.114136
R3212 vdd.n342 vdd.n293 0.114136
R3213 vdd.n343 vdd.n342 0.114136
R3214 vdd.n344 vdd.n343 0.114136
R3215 vdd.n344 vdd.n291 0.114136
R3216 vdd.n352 vdd.n291 0.114136
R3217 vdd.n353 vdd.n352 0.114136
R3218 vdd.n354 vdd.n353 0.114136
R3219 vdd.n354 vdd.n289 0.114136
R3220 vdd.n362 vdd.n289 0.114136
R3221 vdd.n363 vdd.n362 0.114136
R3222 vdd.n364 vdd.n363 0.114136
R3223 vdd.n364 vdd.n287 0.114136
R3224 vdd.n372 vdd.n287 0.114136
R3225 vdd.n373 vdd.n372 0.114136
R3226 vdd.n374 vdd.n373 0.114136
R3227 vdd.n374 vdd.n285 0.114136
R3228 vdd.n381 vdd.n285 0.114136
R3229 vdd.n389 vdd.n388 0.114136
R3230 vdd.n390 vdd.n389 0.114136
R3231 vdd.n390 vdd.n258 0.114136
R3232 vdd.n399 vdd.n258 0.114136
R3233 vdd.n400 vdd.n399 0.114136
R3234 vdd.n401 vdd.n400 0.114136
R3235 vdd.n401 vdd.n244 0.114136
R3236 vdd.n424 vdd.n245 0.114136
R3237 vdd.n420 vdd.n245 0.114136
R3238 vdd.n420 vdd.n419 0.114136
R3239 vdd.n419 vdd.n418 0.114136
R3240 vdd.n418 vdd.n251 0.114136
R3241 vdd.n563 vdd.n562 0.114136
R3242 vdd.n562 vdd.n561 0.114136
R3243 vdd.n561 vdd.n469 0.114136
R3244 vdd.n557 vdd.n469 0.114136
R3245 vdd.n557 vdd.n556 0.114136
R3246 vdd.n556 vdd.n555 0.114136
R3247 vdd.n555 vdd.n474 0.114136
R3248 vdd.n551 vdd.n474 0.114136
R3249 vdd.n551 vdd.n550 0.114136
R3250 vdd.n550 vdd.n549 0.114136
R3251 vdd.n549 vdd.n480 0.114136
R3252 vdd.n545 vdd.n480 0.114136
R3253 vdd.n545 vdd.n544 0.114136
R3254 vdd.n544 vdd.n543 0.114136
R3255 vdd.n543 vdd.n486 0.114136
R3256 vdd.n539 vdd.n486 0.114136
R3257 vdd.n539 vdd.n538 0.114136
R3258 vdd.n538 vdd.n537 0.114136
R3259 vdd.n537 vdd.n492 0.114136
R3260 vdd.n533 vdd.n492 0.114136
R3261 vdd.n533 vdd.n532 0.114136
R3262 vdd.n532 vdd.n531 0.114136
R3263 vdd.n531 vdd.n498 0.114136
R3264 vdd.n527 vdd.n498 0.114136
R3265 vdd.n527 vdd.n526 0.114136
R3266 vdd.n526 vdd.n525 0.114136
R3267 vdd.n525 vdd.n504 0.114136
R3268 vdd.n521 vdd.n504 0.114136
R3269 vdd.n521 vdd.n520 0.114136
R3270 vdd.n520 vdd.n519 0.114136
R3271 vdd.n519 vdd.n510 0.114136
R3272 vdd.n572 vdd.n571 0.114136
R3273 vdd.n573 vdd.n572 0.114136
R3274 vdd.n573 vdd.n441 0.114136
R3275 vdd.n582 vdd.n441 0.114136
R3276 vdd.n583 vdd.n582 0.114136
R3277 vdd.n584 vdd.n583 0.114136
R3278 vdd.n584 vdd.n427 0.114136
R3279 vdd.n607 vdd.n428 0.114136
R3280 vdd.n603 vdd.n428 0.114136
R3281 vdd.n603 vdd.n602 0.114136
R3282 vdd.n602 vdd.n601 0.114136
R3283 vdd.n601 vdd.n434 0.114136
R3284 vdd.n202 vdd.n10 0.114136
R3285 vdd.n210 vdd.n10 0.114136
R3286 vdd.n211 vdd.n210 0.114136
R3287 vdd.n212 vdd.n211 0.114136
R3288 vdd.n212 vdd.n1 0.114136
R3289 vdd.n241 vdd.n2 0.114136
R3290 vdd.n219 vdd.n2 0.114136
R3291 vdd.n220 vdd.n219 0.114136
R3292 vdd.n221 vdd.n220 0.114136
R3293 vdd.n224 vdd.n221 0.114136
R3294 vdd.n166 vdd.n165 0.114136
R3295 vdd.n166 vdd.n31 0.114136
R3296 vdd.n174 vdd.n31 0.114136
R3297 vdd.n175 vdd.n174 0.114136
R3298 vdd.n177 vdd.n175 0.114136
R3299 vdd.n185 vdd.n25 0.114136
R3300 vdd.n186 vdd.n185 0.114136
R3301 vdd.n187 vdd.n186 0.114136
R3302 vdd.n187 vdd.n19 0.114136
R3303 vdd.n195 vdd.n19 0.114136
R3304 vdd.n117 vdd.n102 0.114136
R3305 vdd.n107 vdd.n102 0.114136
R3306 vdd.n108 vdd.n107 0.114136
R3307 vdd.n108 vdd.n53 0.114136
R3308 vdd.n138 vdd.n53 0.114136
R3309 vdd.n146 vdd.n47 0.114136
R3310 vdd.n147 vdd.n146 0.114136
R3311 vdd.n148 vdd.n147 0.114136
R3312 vdd.n148 vdd.n41 0.114136
R3313 vdd.n156 vdd.n41 0.114136
R3314 vdd.n75 vdd.n68 0.114136
R3315 vdd.n84 vdd.n68 0.114136
R3316 vdd.n85 vdd.n84 0.114136
R3317 vdd.n86 vdd.n85 0.114136
R3318 vdd.n86 vdd.n54 0.114136
R3319 vdd.n133 vdd.n55 0.114136
R3320 vdd.n129 vdd.n55 0.114136
R3321 vdd.n129 vdd.n128 0.114136
R3322 vdd.n128 vdd.n127 0.114136
R3323 vdd.n127 vdd.n61 0.114136
R3324 vdd.n303 vdd.n302 0.108455
R3325 vdd.n563 vdd.n468 0.108455
R3326 vdd.n425 vdd.n244 0.0573182
R3327 vdd.n425 vdd.n424 0.0573182
R3328 vdd.n608 vdd.n427 0.0573182
R3329 vdd.n608 vdd.n607 0.0573182
R3330 vdd.n242 vdd.n1 0.0573182
R3331 vdd.n242 vdd.n241 0.0573182
R3332 vdd.n177 vdd.n176 0.0573182
R3333 vdd.n176 vdd.n25 0.0573182
R3334 vdd.n138 vdd.n137 0.0573182
R3335 vdd.n137 vdd.n47 0.0573182
R3336 vdd.n134 vdd.n54 0.0573182
R3337 vdd.n134 vdd.n133 0.0573182
R3338 pbias.n0 pbias.t3 4791.61
R3339 pbias pbias.t3 0.0005
R3340 nb.n0 nb.t0 1100
R3341 nb nb.t0 0.0005
C0 nd12 pbias 0.69513f
C1 nb pbias 14.4489f
C2 vcasc vdd 0.33584f
C3 nsl2 nsl1 1.3569f
C4 nsl3 nsl1 0.27759f
C5 nb ne2 5.17044f
C6 nsl2 vdd 2.30018f
C7 nd055 vdd 0.21047f
C8 pbias ne2 1.49074f
C9 nsl3 vdd 2.16134f
C10 nd12 vdd 4.72535f
C11 pbias nsl1 0.62477f
C12 nb vdd 47.0586f
C13 nd12 vcasc 0.47399f
C14 pbias vdd 16.2162f
C15 nsl2 nsl3 1.27099f
C16 nd12 nsl2 0.28519f
C17 nd055 nd12 0.39363f
C18 ne2 vdd 0.2011f
C19 nd055 nb 0.32404f
C20 nd12 nsl3 0.63852f
C21 nsl1 vdd 2.27914f
C22 nsl2 pbias 0.40978f
C23 nd055 pbias 0.12846f
C24 nd12 nb 2.02713f
C25 nsl3 pbias 0.03025f
C26 nsl3 VSUB 2.84145f
C27 nsl2 VSUB 1.88498f
C28 nsl1 VSUB 1.70374f
C29 ne2 VSUB 3.08013f
C30 nd055 VSUB 2.65452f
C31 vcasc VSUB 2.66213f
C32 nd12 VSUB 8.15945f
C33 vdd VSUB 0.11219p
C34 pbias VSUB 57.8017f
C35 nb VSUB 23.1535f
C36 nb.t0 VSUB 51.9808f
C37 nb.n0 VSUB 17.3269f
C38 pbias.t3 VSUB 58.9526f
C39 pbias.n0 VSUB -24.8417f
C40 vdd.n0 VSUB 0.57919f
C41 vdd.n2 VSUB 0.01309f
C42 vdd.n3 VSUB 0.01309f
C43 vdd.n4 VSUB 0.01309f
C44 vdd.n5 VSUB 0.01071f
C45 vdd.n6 VSUB 0.01071f
C46 vdd.n7 VSUB 0.1619f
C47 vdd.n8 VSUB 0.01071f
C48 vdd.n9 VSUB 0.01309f
C49 vdd.n10 VSUB 0.01309f
C50 vdd.n11 VSUB 0.01309f
C51 vdd.n12 VSUB 0.01071f
C52 vdd.n13 VSUB 0.1619f
C53 vdd.n14 VSUB 0.01071f
C54 vdd.n15 VSUB 0.01309f
C55 vdd.n16 VSUB 0.1619f
C56 vdd.n17 VSUB 0.01071f
C57 vdd.n18 VSUB 0.01309f
C58 vdd.n19 VSUB 0.01309f
C59 vdd.n20 VSUB 0.01309f
C60 vdd.n21 VSUB 0.01071f
C61 vdd.n22 VSUB 0.1619f
C62 vdd.n23 VSUB 0.01071f
C63 vdd.n24 VSUB 0.01309f
C64 vdd.n26 VSUB 0.01309f
C65 vdd.n27 VSUB 0.01071f
C66 vdd.n28 VSUB 0.1619f
C67 vdd.n29 VSUB 0.01071f
C68 vdd.n30 VSUB 0.01309f
C69 vdd.n31 VSUB 0.01309f
C70 vdd.n32 VSUB 0.01309f
C71 vdd.n33 VSUB 0.01071f
C72 vdd.n34 VSUB 0.1619f
C73 vdd.n35 VSUB 0.01071f
C74 vdd.n36 VSUB 0.01309f
C75 vdd.n37 VSUB 0.01979f
C76 vdd.n38 VSUB 0.1619f
C77 vdd.n39 VSUB 0.01071f
C78 vdd.n40 VSUB 0.01309f
C79 vdd.n41 VSUB 0.01309f
C80 vdd.n42 VSUB 0.01309f
C81 vdd.n43 VSUB 0.01071f
C82 vdd.n44 VSUB 0.1619f
C83 vdd.n45 VSUB 0.01071f
C84 vdd.n46 VSUB 0.01309f
C85 vdd.n48 VSUB 0.01309f
C86 vdd.n49 VSUB 0.01071f
C87 vdd.n50 VSUB 0.1619f
C88 vdd.n51 VSUB 0.01071f
C89 vdd.n52 VSUB 0.01309f
C90 vdd.n53 VSUB 0.01309f
C91 vdd.t1 VSUB 27.9744f
C92 vdd.n55 VSUB 0.01309f
C93 vdd.n56 VSUB 0.01309f
C94 vdd.n57 VSUB 0.01071f
C95 vdd.n58 VSUB 0.01071f
C96 vdd.n59 VSUB 0.01071f
C97 vdd.n60 VSUB 0.01309f
C98 vdd.n61 VSUB 0.05059f
C99 vdd.n62 VSUB 0.01071f
C100 vdd.n63 VSUB 0.01071f
C101 vdd.n64 VSUB 0.01071f
C102 vdd.n65 VSUB 0.1619f
C103 vdd.n66 VSUB 0.01071f
C104 vdd.n67 VSUB 0.01309f
C105 vdd.n68 VSUB 0.01309f
C106 vdd.n69 VSUB 0.01309f
C107 vdd.n70 VSUB 0.01071f
C108 vdd.n71 VSUB 0.3522f
C109 vdd.n72 VSUB 0.01071f
C110 vdd.n73 VSUB 0.01309f
C111 vdd.n74 VSUB 0.06295f
C112 vdd.n75 VSUB 0.05059f
C113 vdd.n76 VSUB 0.01309f
C114 vdd.n77 VSUB 0.01071f
C115 vdd.n78 VSUB 0.4416f
C116 vdd.n79 VSUB 0.1619f
C117 vdd.n80 VSUB 0.1619f
C118 vdd.n81 VSUB 0.1619f
C119 vdd.n82 VSUB 0.01071f
C120 vdd.n83 VSUB 0.01309f
C121 vdd.n84 VSUB 0.01309f
C122 vdd.n85 VSUB 0.01309f
C123 vdd.n86 VSUB 0.01309f
C124 vdd.n87 VSUB 0.01309f
C125 vdd.n88 VSUB 0.01071f
C126 vdd.n89 VSUB 0.01071f
C127 vdd.n90 VSUB 0.12142f
C128 vdd.t0 VSUB 0.08095f
C129 vdd.n91 VSUB 0.12142f
C130 vdd.n92 VSUB 0.1619f
C131 vdd.n93 VSUB 0.1619f
C132 vdd.n94 VSUB 0.01071f
C133 vdd.n95 VSUB 0.1619f
C134 vdd.n96 VSUB 0.1619f
C135 vdd.n97 VSUB 0.1619f
C136 vdd.n98 VSUB 0.1619f
C137 vdd.n99 VSUB 0.1619f
C138 vdd.n100 VSUB 0.01071f
C139 vdd.n101 VSUB 0.01309f
C140 vdd.n102 VSUB 0.01309f
C141 vdd.n103 VSUB 0.01309f
C142 vdd.n104 VSUB 0.01071f
C143 vdd.n105 VSUB 0.1619f
C144 vdd.n106 VSUB 0.01071f
C145 vdd.n107 VSUB 0.01309f
C146 vdd.n108 VSUB 0.01309f
C147 vdd.n109 VSUB 0.01309f
C148 vdd.n110 VSUB 0.01309f
C149 vdd.n111 VSUB 0.01071f
C150 vdd.n112 VSUB 0.1619f
C151 vdd.n113 VSUB 0.1619f
C152 vdd.n114 VSUB 0.1619f
C153 vdd.n115 VSUB 0.01071f
C154 vdd.n116 VSUB 0.01309f
C155 vdd.n117 VSUB 0.05059f
C156 vdd.n118 VSUB 0.02747f
C157 vdd.n119 VSUB 0.01979f
C158 vdd.n120 VSUB 0.48569f
C159 vdd.n121 VSUB 0.48569f
C160 vdd.n122 VSUB 0.01979f
C161 vdd.n123 VSUB 0.02747f
C162 vdd.n124 VSUB 0.01309f
C163 vdd.n125 VSUB 0.01309f
C164 vdd.n126 VSUB 0.01309f
C165 vdd.n127 VSUB 0.01309f
C166 vdd.n128 VSUB 0.01309f
C167 vdd.n129 VSUB 0.01309f
C168 vdd.n130 VSUB 0.01309f
C169 vdd.n131 VSUB 0.01309f
C170 vdd.n132 VSUB 0.01309f
C171 vdd.n134 VSUB 0.11732f
C172 vdd.n135 VSUB 1.81086f
C173 vdd.n136 VSUB 0.57919f
C174 vdd.n137 VSUB 0.11732f
C175 vdd.n139 VSUB 0.01309f
C176 vdd.n140 VSUB 0.01071f
C177 vdd.n141 VSUB 0.12142f
C178 vdd.t4 VSUB 0.08095f
C179 vdd.n142 VSUB 0.12142f
C180 vdd.n143 VSUB 0.1619f
C181 vdd.n144 VSUB 0.01071f
C182 vdd.n145 VSUB 0.01309f
C183 vdd.n146 VSUB 0.01309f
C184 vdd.n147 VSUB 0.01309f
C185 vdd.n148 VSUB 0.01309f
C186 vdd.n149 VSUB 0.01309f
C187 vdd.n150 VSUB 0.01071f
C188 vdd.n151 VSUB 0.1619f
C189 vdd.n152 VSUB 0.1619f
C190 vdd.n153 VSUB 0.1619f
C191 vdd.n154 VSUB 0.01071f
C192 vdd.n155 VSUB 0.01309f
C193 vdd.n156 VSUB 0.05059f
C194 vdd.n157 VSUB 0.02747f
C195 vdd.n158 VSUB 0.01979f
C196 vdd.n159 VSUB 0.48569f
C197 vdd.n160 VSUB 0.48569f
C198 vdd.n161 VSUB 0.1619f
C199 vdd.n162 VSUB 0.01071f
C200 vdd.n163 VSUB 0.01309f
C201 vdd.n164 VSUB 0.02747f
C202 vdd.n165 VSUB 0.05059f
C203 vdd.n166 VSUB 0.01309f
C204 vdd.n167 VSUB 0.01309f
C205 vdd.n168 VSUB 0.01071f
C206 vdd.n169 VSUB 0.1619f
C207 vdd.n170 VSUB 0.1619f
C208 vdd.n171 VSUB 0.1619f
C209 vdd.n172 VSUB 0.01071f
C210 vdd.n173 VSUB 0.01309f
C211 vdd.n174 VSUB 0.01309f
C212 vdd.n175 VSUB 0.01309f
C213 vdd.n176 VSUB 0.11732f
C214 vdd.n178 VSUB 0.01309f
C215 vdd.n179 VSUB 0.01071f
C216 vdd.n180 VSUB 0.12142f
C217 vdd.t5 VSUB 0.08095f
C218 vdd.n181 VSUB 0.12142f
C219 vdd.n182 VSUB 0.1619f
C220 vdd.n183 VSUB 0.01071f
C221 vdd.n184 VSUB 0.01309f
C222 vdd.n185 VSUB 0.01309f
C223 vdd.n186 VSUB 0.01309f
C224 vdd.n187 VSUB 0.01309f
C225 vdd.n188 VSUB 0.01309f
C226 vdd.n189 VSUB 0.01071f
C227 vdd.n190 VSUB 0.1619f
C228 vdd.n191 VSUB 0.1619f
C229 vdd.n192 VSUB 0.1619f
C230 vdd.n193 VSUB 0.01071f
C231 vdd.n194 VSUB 0.01309f
C232 vdd.n195 VSUB 0.05059f
C233 vdd.n196 VSUB 0.02747f
C234 vdd.n197 VSUB 0.01979f
C235 vdd.n198 VSUB 0.48569f
C236 vdd.n199 VSUB 0.48569f
C237 vdd.n200 VSUB 0.01979f
C238 vdd.n201 VSUB 0.02747f
C239 vdd.n202 VSUB 0.05059f
C240 vdd.n203 VSUB 0.01309f
C241 vdd.n204 VSUB 0.01071f
C242 vdd.n205 VSUB 0.1619f
C243 vdd.n206 VSUB 0.1619f
C244 vdd.n207 VSUB 0.1619f
C245 vdd.n208 VSUB 0.01071f
C246 vdd.n209 VSUB 0.01309f
C247 vdd.n210 VSUB 0.01309f
C248 vdd.n211 VSUB 0.01309f
C249 vdd.n212 VSUB 0.01309f
C250 vdd.n213 VSUB 0.01309f
C251 vdd.n214 VSUB 0.01071f
C252 vdd.n215 VSUB 0.1619f
C253 vdd.n216 VSUB 0.12142f
C254 vdd.t3 VSUB 0.08095f
C255 vdd.n217 VSUB 0.1619f
C256 vdd.n218 VSUB 0.01071f
C257 vdd.n219 VSUB 0.01309f
C258 vdd.n220 VSUB 0.01309f
C259 vdd.n221 VSUB 0.01309f
C260 vdd.n222 VSUB 0.01309f
C261 vdd.n223 VSUB 0.01071f
C262 vdd.n224 VSUB 0.05059f
C263 vdd.n225 VSUB 0.06295f
C264 vdd.n226 VSUB 0.01309f
C265 vdd.n227 VSUB 0.01071f
C266 vdd.n228 VSUB 0.3522f
C267 vdd.n229 VSUB 0.4416f
C268 vdd.n230 VSUB 0.1619f
C269 vdd.n231 VSUB 0.01071f
C270 vdd.n232 VSUB 0.01309f
C271 vdd.n233 VSUB 0.01309f
C272 vdd.n234 VSUB 0.01309f
C273 vdd.n235 VSUB 0.01071f
C274 vdd.n236 VSUB 0.1619f
C275 vdd.n237 VSUB 0.1619f
C276 vdd.n238 VSUB 0.12142f
C277 vdd.n239 VSUB 0.01071f
C278 vdd.n240 VSUB 0.01309f
C279 vdd.n242 VSUB 0.11732f
C280 vdd.n243 VSUB 0.44205f
C281 vdd.t2 VSUB 0.28465f
C282 vdd.n245 VSUB 0.01309f
C283 vdd.n246 VSUB 0.01309f
C284 vdd.n247 VSUB 0.01071f
C285 vdd.n248 VSUB 0.01071f
C286 vdd.n249 VSUB 0.01071f
C287 vdd.n250 VSUB 0.01309f
C288 vdd.n251 VSUB 0.05059f
C289 vdd.n252 VSUB 0.01071f
C290 vdd.n253 VSUB 0.01071f
C291 vdd.n254 VSUB 0.01071f
C292 vdd.n255 VSUB 0.4476f
C293 vdd.n256 VSUB 0.01071f
C294 vdd.n257 VSUB 0.01309f
C295 vdd.n258 VSUB 0.01309f
C296 vdd.n259 VSUB 0.01309f
C297 vdd.n260 VSUB 0.01071f
C298 vdd.n261 VSUB 0.4476f
C299 vdd.n262 VSUB 0.01071f
C300 vdd.n263 VSUB 0.01309f
C301 vdd.t7 VSUB 0.45539f
C302 vdd.n264 VSUB 0.6308f
C303 vdd.n265 VSUB 0.033f
C304 vdd.n266 VSUB 0.02638f
C305 vdd.n283 VSUB 0.01071f
C306 vdd.n284 VSUB 0.01309f
C307 vdd.n285 VSUB 0.01309f
C308 vdd.n286 VSUB 0.01309f
C309 vdd.n287 VSUB 0.01309f
C310 vdd.n288 VSUB 0.01309f
C311 vdd.n289 VSUB 0.01309f
C312 vdd.n290 VSUB 0.01309f
C313 vdd.n291 VSUB 0.01309f
C314 vdd.n292 VSUB 0.01309f
C315 vdd.n293 VSUB 0.01309f
C316 vdd.n294 VSUB 0.01309f
C317 vdd.n295 VSUB 0.01309f
C318 vdd.n296 VSUB 0.01309f
C319 vdd.n297 VSUB 0.01309f
C320 vdd.n298 VSUB 0.01309f
C321 vdd.n299 VSUB 0.01309f
C322 vdd.n300 VSUB 0.01071f
C323 vdd.n301 VSUB 0.01277f
C324 vdd.n302 VSUB 0.02534f
C325 vdd.n303 VSUB 0.01277f
C326 vdd.n304 VSUB 0.01309f
C327 vdd.n305 VSUB 0.01309f
C328 vdd.n306 VSUB 0.01071f
C329 vdd.n307 VSUB 0.01071f
C330 vdd.n308 VSUB 0.01309f
C331 vdd.n309 VSUB 0.01071f
C332 vdd.n310 VSUB 0.01071f
C333 vdd.n311 VSUB 0.01309f
C334 vdd.n312 VSUB 0.01309f
C335 vdd.n313 VSUB 0.01309f
C336 vdd.n314 VSUB 0.01309f
C337 vdd.n315 VSUB 0.01309f
C338 vdd.n316 VSUB 0.01071f
C339 vdd.n317 VSUB 0.01071f
C340 vdd.n318 VSUB 0.01309f
C341 vdd.n319 VSUB 0.01071f
C342 vdd.n320 VSUB 0.01071f
C343 vdd.n321 VSUB 0.01309f
C344 vdd.n322 VSUB 0.01309f
C345 vdd.n323 VSUB 0.01309f
C346 vdd.n324 VSUB 0.01309f
C347 vdd.n325 VSUB 0.01309f
C348 vdd.n326 VSUB 0.01071f
C349 vdd.n327 VSUB 0.01071f
C350 vdd.n328 VSUB 0.01309f
C351 vdd.n329 VSUB 0.01071f
C352 vdd.n330 VSUB 0.01071f
C353 vdd.n331 VSUB 0.01309f
C354 vdd.n332 VSUB 0.01309f
C355 vdd.n333 VSUB 0.01309f
C356 vdd.n334 VSUB 0.01309f
C357 vdd.n335 VSUB 0.01309f
C358 vdd.n336 VSUB 0.01071f
C359 vdd.n337 VSUB 0.01071f
C360 vdd.n338 VSUB 0.01309f
C361 vdd.n339 VSUB 0.01071f
C362 vdd.n340 VSUB 0.01071f
C363 vdd.n341 VSUB 0.01309f
C364 vdd.n342 VSUB 0.01309f
C365 vdd.n343 VSUB 0.01309f
C366 vdd.n344 VSUB 0.01309f
C367 vdd.n345 VSUB 0.01309f
C368 vdd.n346 VSUB 0.01071f
C369 vdd.n347 VSUB 0.01071f
C370 vdd.n348 VSUB 0.01309f
C371 vdd.n349 VSUB 0.01071f
C372 vdd.n350 VSUB 0.01071f
C373 vdd.n351 VSUB 0.01309f
C374 vdd.n352 VSUB 0.01309f
C375 vdd.n353 VSUB 0.01309f
C376 vdd.n354 VSUB 0.01309f
C377 vdd.n355 VSUB 0.01309f
C378 vdd.n356 VSUB 0.01071f
C379 vdd.n357 VSUB 0.01071f
C380 vdd.n358 VSUB 0.01309f
C381 vdd.n359 VSUB 0.01071f
C382 vdd.n360 VSUB 0.01071f
C383 vdd.n361 VSUB 0.01309f
C384 vdd.n362 VSUB 0.01309f
C385 vdd.n363 VSUB 0.01309f
C386 vdd.n364 VSUB 0.01309f
C387 vdd.n365 VSUB 0.01309f
C388 vdd.n366 VSUB 0.01071f
C389 vdd.n367 VSUB 0.01071f
C390 vdd.n368 VSUB 0.01309f
C391 vdd.n369 VSUB 0.01071f
C392 vdd.n370 VSUB 0.01071f
C393 vdd.n371 VSUB 0.01309f
C394 vdd.n372 VSUB 0.01309f
C395 vdd.n373 VSUB 0.01309f
C396 vdd.n374 VSUB 0.01309f
C397 vdd.n375 VSUB 0.01309f
C398 vdd.n376 VSUB 0.01071f
C399 vdd.n377 VSUB 0.01071f
C400 vdd.n378 VSUB 0.01309f
C401 vdd.n379 VSUB 0.01071f
C402 vdd.n380 VSUB 0.01309f
C403 vdd.n381 VSUB 0.03752f
C404 vdd.n382 VSUB 0.0154f
C405 vdd.n384 VSUB 1.16599f
C406 vdd.n385 VSUB 0.89295f
C407 vdd.n386 VSUB 0.02172f
C408 vdd.n387 VSUB 0.02612f
C409 vdd.n388 VSUB 0.01421f
C410 vdd.n389 VSUB 0.01309f
C411 vdd.n390 VSUB 0.01309f
C412 vdd.n391 VSUB 0.01309f
C413 vdd.n392 VSUB 0.01071f
C414 vdd.n393 VSUB 0.4476f
C415 vdd.n394 VSUB 0.4476f
C416 vdd.n395 VSUB 0.4476f
C417 vdd.n396 VSUB 0.4476f
C418 vdd.n397 VSUB 0.01071f
C419 vdd.n398 VSUB 0.01309f
C420 vdd.n399 VSUB 0.01309f
C421 vdd.n400 VSUB 0.01309f
C422 vdd.n401 VSUB 0.01309f
C423 vdd.n402 VSUB 0.01309f
C424 vdd.n403 VSUB 0.01071f
C425 vdd.n404 VSUB 0.01071f
C426 vdd.n405 VSUB 0.3357f
C427 vdd.t6 VSUB 0.2238f
C428 vdd.n406 VSUB 0.3357f
C429 vdd.n407 VSUB 0.4476f
C430 vdd.n408 VSUB 0.4476f
C431 vdd.n409 VSUB 0.01071f
C432 vdd.n410 VSUB 0.4476f
C433 vdd.n411 VSUB 0.4476f
C434 vdd.n412 VSUB 1.66419f
C435 vdd.n413 VSUB 0.555f
C436 vdd.n414 VSUB 0.06605f
C437 vdd.n415 VSUB 0.01309f
C438 vdd.n416 VSUB 0.01309f
C439 vdd.n417 VSUB 0.01309f
C440 vdd.n418 VSUB 0.01309f
C441 vdd.n419 VSUB 0.01309f
C442 vdd.n420 VSUB 0.01309f
C443 vdd.n421 VSUB 0.01309f
C444 vdd.n422 VSUB 0.01309f
C445 vdd.n423 VSUB 0.01309f
C446 vdd.n425 VSUB 0.07829f
C447 vdd.n426 VSUB 2.6551f
C448 vdd.n428 VSUB 0.01309f
C449 vdd.n429 VSUB 0.01309f
C450 vdd.n430 VSUB 0.01071f
C451 vdd.n431 VSUB 0.01071f
C452 vdd.n432 VSUB 0.01071f
C453 vdd.n433 VSUB 0.01309f
C454 vdd.n434 VSUB 0.05059f
C455 vdd.n435 VSUB 0.01071f
C456 vdd.n436 VSUB 0.01071f
C457 vdd.n437 VSUB 0.01071f
C458 vdd.n438 VSUB 0.4476f
C459 vdd.n439 VSUB 0.01071f
C460 vdd.n440 VSUB 0.01309f
C461 vdd.n441 VSUB 0.01309f
C462 vdd.n442 VSUB 0.01309f
C463 vdd.n443 VSUB 0.01071f
C464 vdd.n444 VSUB 0.4476f
C465 vdd.n445 VSUB 0.01071f
C466 vdd.n446 VSUB 0.01309f
C467 vdd.t9 VSUB 0.45539f
C468 vdd.n447 VSUB 0.6308f
C469 vdd.n448 VSUB 0.033f
C470 vdd.n449 VSUB 0.02638f
C471 vdd.n466 VSUB 0.01071f
C472 vdd.n467 VSUB 0.01309f
C473 vdd.n468 VSUB 0.02534f
C474 vdd.n469 VSUB 0.01309f
C475 vdd.n470 VSUB 0.01071f
C476 vdd.n471 VSUB 0.01071f
C477 vdd.n472 VSUB 0.01071f
C478 vdd.n473 VSUB 0.01309f
C479 vdd.n474 VSUB 0.01309f
C480 vdd.n475 VSUB 0.01071f
C481 vdd.n476 VSUB 0.01071f
C482 vdd.n477 VSUB 0.01071f
C483 vdd.n478 VSUB 0.01071f
C484 vdd.n479 VSUB 0.01309f
C485 vdd.n480 VSUB 0.01309f
C486 vdd.n481 VSUB 0.01071f
C487 vdd.n482 VSUB 0.01071f
C488 vdd.n483 VSUB 0.01071f
C489 vdd.n484 VSUB 0.01071f
C490 vdd.n485 VSUB 0.01309f
C491 vdd.n486 VSUB 0.01309f
C492 vdd.n487 VSUB 0.01071f
C493 vdd.n488 VSUB 0.01071f
C494 vdd.n489 VSUB 0.01071f
C495 vdd.n490 VSUB 0.01071f
C496 vdd.n491 VSUB 0.01309f
C497 vdd.n492 VSUB 0.01309f
C498 vdd.n493 VSUB 0.01071f
C499 vdd.n494 VSUB 0.01071f
C500 vdd.n495 VSUB 0.01071f
C501 vdd.n496 VSUB 0.01071f
C502 vdd.n497 VSUB 0.01309f
C503 vdd.n498 VSUB 0.01309f
C504 vdd.n499 VSUB 0.01071f
C505 vdd.n500 VSUB 0.01071f
C506 vdd.n501 VSUB 0.01071f
C507 vdd.n502 VSUB 0.01071f
C508 vdd.n503 VSUB 0.01309f
C509 vdd.n504 VSUB 0.01309f
C510 vdd.n505 VSUB 0.01071f
C511 vdd.n506 VSUB 0.01071f
C512 vdd.n507 VSUB 0.01071f
C513 vdd.n508 VSUB 0.01071f
C514 vdd.n509 VSUB 0.01309f
C515 vdd.n510 VSUB 0.03752f
C516 vdd.n511 VSUB 0.01071f
C517 vdd.n512 VSUB 0.01071f
C518 vdd.n513 VSUB 0.01071f
C519 vdd.n514 VSUB 0.01071f
C520 vdd.n515 VSUB 0.0154f
C521 vdd.n516 VSUB 0.01309f
C522 vdd.n517 VSUB 0.01309f
C523 vdd.n518 VSUB 0.01309f
C524 vdd.n519 VSUB 0.01309f
C525 vdd.n520 VSUB 0.01309f
C526 vdd.n521 VSUB 0.01309f
C527 vdd.n522 VSUB 0.01309f
C528 vdd.n523 VSUB 0.01309f
C529 vdd.n524 VSUB 0.01309f
C530 vdd.n525 VSUB 0.01309f
C531 vdd.n526 VSUB 0.01309f
C532 vdd.n527 VSUB 0.01309f
C533 vdd.n528 VSUB 0.01309f
C534 vdd.n529 VSUB 0.01309f
C535 vdd.n530 VSUB 0.01309f
C536 vdd.n531 VSUB 0.01309f
C537 vdd.n532 VSUB 0.01309f
C538 vdd.n533 VSUB 0.01309f
C539 vdd.n534 VSUB 0.01309f
C540 vdd.n535 VSUB 0.01309f
C541 vdd.n536 VSUB 0.01309f
C542 vdd.n537 VSUB 0.01309f
C543 vdd.n538 VSUB 0.01309f
C544 vdd.n539 VSUB 0.01309f
C545 vdd.n540 VSUB 0.01309f
C546 vdd.n541 VSUB 0.01309f
C547 vdd.n542 VSUB 0.01309f
C548 vdd.n543 VSUB 0.01309f
C549 vdd.n544 VSUB 0.01309f
C550 vdd.n545 VSUB 0.01309f
C551 vdd.n546 VSUB 0.01309f
C552 vdd.n547 VSUB 0.01309f
C553 vdd.n548 VSUB 0.01309f
C554 vdd.n549 VSUB 0.01309f
C555 vdd.n550 VSUB 0.01309f
C556 vdd.n551 VSUB 0.01309f
C557 vdd.n552 VSUB 0.01309f
C558 vdd.n553 VSUB 0.01309f
C559 vdd.n554 VSUB 0.01309f
C560 vdd.n555 VSUB 0.01309f
C561 vdd.n556 VSUB 0.01309f
C562 vdd.n557 VSUB 0.01309f
C563 vdd.n558 VSUB 0.01309f
C564 vdd.n559 VSUB 0.01309f
C565 vdd.n560 VSUB 0.01309f
C566 vdd.n561 VSUB 0.01309f
C567 vdd.n562 VSUB 0.01309f
C568 vdd.n563 VSUB 0.01277f
C569 vdd.n564 VSUB 0.01277f
C570 vdd.n565 VSUB 0.01071f
C571 vdd.n567 VSUB 1.16599f
C572 vdd.n568 VSUB 0.89295f
C573 vdd.n569 VSUB 0.02172f
C574 vdd.n570 VSUB 0.02612f
C575 vdd.n571 VSUB 0.01421f
C576 vdd.n572 VSUB 0.01309f
C577 vdd.n573 VSUB 0.01309f
C578 vdd.n574 VSUB 0.01309f
C579 vdd.n575 VSUB 0.01071f
C580 vdd.n576 VSUB 0.4476f
C581 vdd.n577 VSUB 0.4476f
C582 vdd.n578 VSUB 0.4476f
C583 vdd.n579 VSUB 0.4476f
C584 vdd.n580 VSUB 0.01071f
C585 vdd.n581 VSUB 0.01309f
C586 vdd.n582 VSUB 0.01309f
C587 vdd.n583 VSUB 0.01309f
C588 vdd.n584 VSUB 0.01309f
C589 vdd.n585 VSUB 0.01309f
C590 vdd.n586 VSUB 0.01071f
C591 vdd.n587 VSUB 0.01071f
C592 vdd.n588 VSUB 0.3357f
C593 vdd.t8 VSUB 0.2238f
C594 vdd.n589 VSUB 0.3357f
C595 vdd.n590 VSUB 0.4476f
C596 vdd.n591 VSUB 0.4476f
C597 vdd.n592 VSUB 0.01071f
C598 vdd.n593 VSUB 0.4476f
C599 vdd.n594 VSUB 0.4476f
C600 vdd.n595 VSUB 1.66419f
C601 vdd.n596 VSUB 0.555f
C602 vdd.n597 VSUB 0.06605f
C603 vdd.n598 VSUB 0.01309f
C604 vdd.n599 VSUB 0.01309f
C605 vdd.n600 VSUB 0.01309f
C606 vdd.n601 VSUB 0.01309f
C607 vdd.n602 VSUB 0.01309f
C608 vdd.n603 VSUB 0.01309f
C609 vdd.n604 VSUB 0.01309f
C610 vdd.n605 VSUB 0.01309f
C611 vdd.n606 VSUB 0.01309f
C612 vdd.n608 VSUB 0.07829f
C613 vdd.n609 VSUB 0.56298f
C614 a_365_8758.t1 VSUB 0.05519f
C615 a_365_8758.t0 VSUB 0.05519f
C616 a_365_7248.t1 VSUB 0.88341f
C617 a_365_7248.t0 VSUB 0.88376f
C618 a_845_7248.t1 VSUB 0.14028f
C619 a_845_7248.t0 VSUB 0.14028f
C620 a_1325_8758.t1 VSUB 0.10397f
C621 a_1325_8758.t0 VSUB 0.10397f
C622 a_1805_7248.t1 VSUB 0.13824f
C623 a_1805_7248.t0 VSUB 0.13824f
C624 a_2285_8758.t1 VSUB 0.10397f
C625 a_2285_8758.t0 VSUB 0.10397f
C626 a_2765_7248.t1 VSUB 0.13805f
C627 a_2765_7248.t0 VSUB 0.13805f
C628 a_3245_8758.t1 VSUB 0.05504f
C629 a_3245_8758.t0 VSUB 0.05504f
C630 a_3725_7248.t1 VSUB 0.08531f
C631 a_3725_7248.t0 VSUB 0.08531f
C632 a_365_6458.t1 VSUB 0.1456f
C633 a_365_6458.t0 VSUB 0.1456f
C634 a_365_4948.t1 VSUB 1.34236f
C635 a_365_4948.t0 VSUB 1.34224f
C636 a_845_4948.t1 VSUB 0.15727f
C637 a_845_4948.t0 VSUB 0.15727f
C638 a_1325_6458.t1 VSUB 0.18678f
C639 a_1325_6458.t0 VSUB 0.18678f
C640 nd12.t1 VSUB 3.03868f
C641 nd12.t2 VSUB 0.25473f
C642 nd12.n0 VSUB 1.75838f
C643 nd12.t3 VSUB 0.16266f
C644 nd12.t0 VSUB 0.16041f
C645 nd12.n1 VSUB 2.42361f
C646 nd12.n2 VSUB 2.38665f
C647 a_2285_6458.t1 VSUB 0.18678f
C648 a_2285_6458.t0 VSUB 0.18678f
C649 a_2765_4948.t1 VSUB 0.15632f
C650 a_2765_4948.t0 VSUB 0.15632f
C651 a_3245_6458.t1 VSUB 0.18627f
C652 a_3245_6458.t0 VSUB 0.18627f
C653 a_3725_4948.t1 VSUB 0.14724f
C654 a_3725_4948.t0 VSUB 0.14724f
C655 a_4205_6458.t1 VSUB 0.17771f
C656 a_4205_6458.t0 VSUB 0.17771f
C657 a_4685_4948.t1 VSUB 0.19407f
C658 a_4685_4948.t0 VSUB 0.19407f
C659 vcasc.t1 VSUB 0.17539f
C660 vcasc.t0 VSUB 0.22195f
C661 vcasc.n0 VSUB 1.22605f
C662 a_5645_6458.t1 VSUB 0.17031f
C663 a_5645_6458.t0 VSUB 0.17031f
C664 a_6125_4948.t1 VSUB 0.16979f
C665 a_6125_4948.t0 VSUB 0.16979f
C666 a_6605_6458.t1 VSUB 0.16409f
C667 a_6605_6458.t0 VSUB 0.16409f
C668 a_7085_4948.t1 VSUB 0.17102f
C669 a_7085_4948.t0 VSUB 0.17102f
C670 a_7565_6458.t1 VSUB 0.16567f
C671 a_7565_6458.t0 VSUB 0.16567f
C672 nd055.t0 VSUB 0.18634f
C673 nd055.t1 VSUB 0.18741f
C674 nd055.n0 VSUB 1.14581f
C675 a_8525_6458.t1 VSUB 0.19446f
C676 a_8525_6458.t0 VSUB 0.19446f
C677 a_365_4158.t1 VSUB 0.1673f
C678 a_365_4158.t0 VSUB 0.1673f
C679 a_365_2648.t1 VSUB 0.81198f
C680 a_365_2648.t0 VSUB 0.81205f
C681 a_845_2648.t1 VSUB 0.14431f
C682 a_845_2648.t0 VSUB 0.14431f
C683 a_1325_4158.t1 VSUB 0.20186f
C684 a_1325_4158.t0 VSUB 0.20186f
C685 a_1805_2648.t1 VSUB 0.13632f
C686 a_1805_2648.t0 VSUB 0.13632f
C687 a_2285_4158.t1 VSUB 0.21228f
C688 a_2285_4158.t0 VSUB 0.21228f
C689 a_2765_2648.t1 VSUB 0.13498f
C690 a_2765_2648.t0 VSUB 0.13498f
C691 a_3245_4158.t1 VSUB 0.19891f
C692 a_3245_4158.t0 VSUB 0.19891f
C693 a_3725_2648.t1 VSUB 0.13498f
C694 a_3725_2648.t0 VSUB 0.13498f
C695 a_4205_4158.t1 VSUB 0.20121f
C696 a_4205_4158.t0 VSUB 0.20121f
C697 a_4685_2648.t1 VSUB 0.13576f
C698 a_4685_2648.t0 VSUB 0.13576f
C699 a_5165_4158.t1 VSUB 0.27737f
C700 a_5165_4158.t0 VSUB 0.27737f
C701 a_5645_2648.t1 VSUB 0.13576f
C702 a_5645_2648.t0 VSUB 0.13576f
C703 a_6125_4158.t1 VSUB 0.21875f
C704 a_6125_4158.t0 VSUB 0.21875f
C705 a_6605_2648.t1 VSUB 0.13498f
C706 a_6605_2648.t0 VSUB 0.13498f
C707 a_7085_4158.t1 VSUB 0.21781f
C708 a_7085_4158.t0 VSUB 0.21781f
C709 a_7565_2648.t1 VSUB 0.13803f
C710 a_7565_2648.t0 VSUB 0.13803f
C711 a_8045_4158.t1 VSUB 0.28526f
C712 a_8045_4158.t0 VSUB 0.28526f
C713 a_8525_2648.t1 VSUB 0.13869f
C714 a_8525_2648.t0 VSUB 0.13869f
C715 a_365_1858.t1 VSUB 0.16585f
C716 a_365_1858.t0 VSUB 0.16585f
C717 a_845_348.t1 VSUB 0.1103f
C718 a_845_348.t0 VSUB 0.1103f
C719 a_1325_1858.t1 VSUB 0.17815f
C720 a_1325_1858.t0 VSUB 0.17815f
C721 a_1805_348.t1 VSUB 0.10467f
C722 a_1805_348.t0 VSUB 0.10467f
C723 a_2285_1858.t1 VSUB 0.17564f
C724 a_2285_1858.t0 VSUB 0.17564f
C725 a_2765_348.t1 VSUB 0.10405f
C726 a_2765_348.t0 VSUB 0.10405f
C727 a_3245_1858.t1 VSUB 0.17564f
C728 a_3245_1858.t0 VSUB 0.17564f
C729 a_3725_348.t1 VSUB 0.10405f
C730 a_3725_348.t0 VSUB 0.10405f
C731 a_4205_1858.t1 VSUB 0.17564f
C732 a_4205_1858.t0 VSUB 0.17564f
C733 a_4685_348.t1 VSUB 0.10405f
C734 a_4685_348.t0 VSUB 0.10405f
C735 a_5165_1858.t1 VSUB 0.17564f
C736 a_5165_1858.t0 VSUB 0.17564f
C737 a_5645_348.t1 VSUB 0.10405f
C738 a_5645_348.t0 VSUB 0.10405f
C739 a_6125_1858.t1 VSUB 0.17564f
C740 a_6125_1858.t0 VSUB 0.17564f
C741 a_6605_348.t1 VSUB 0.10405f
C742 a_6605_348.t0 VSUB 0.10405f
C743 a_7085_1858.t1 VSUB 0.17582f
C744 a_7085_1858.t0 VSUB 0.17582f
C745 a_7565_348.t1 VSUB 0.10406f
C746 a_7565_348.t0 VSUB 0.10406f
C747 a_8045_1858.t1 VSUB 0.17814f
C748 a_8045_1858.t0 VSUB 0.17814f
C749 a_8525_348.t1 VSUB 0.06519f
C750 a_8525_348.t0 VSUB 0.06519f
C751 ne2.n0 VSUB -1.86494f
C752 ne2.t0 VSUB 2.39936f
C753 ne2.t2 VSUB 0.4681f
C754 ne2.n1 VSUB 1.5359f
C755 ne2.t3 VSUB 0.53442f
C756 ne2.t1 VSUB 0.4681f
C757 ne2.n2 VSUB 1.64495f
C758 ne2.n3 VSUB 1.37838f
C759 nsl1.t1 VSUB 0.19385f
C760 nsl1.n0 VSUB 1.06352f
C761 nsl1.t0 VSUB 2.71216f
C762 nsl1.t2 VSUB 0.21498f
C763 nsl2.t2 VSUB 0.23749f
C764 nsl2.n0 VSUB 1.37151f
C765 nsl2.t1 VSUB 3.28278f
C766 nsl2.t0 VSUB 0.26449f
C767 nsl3.t2 VSUB 0.18283f
C768 nsl3.n0 VSUB 1.11072f
C769 nsl3.t1 VSUB 2.49226f
C770 nsl3.t0 VSUB 0.20465f
.ends
