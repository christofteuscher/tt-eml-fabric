* Extracted by KLayout with SKY130 LVS runset on : 24/07/2026 14:14

.SUBCKT ota1b VSUB inn inp out pbias vdd
M$1 \$2 \$2 VSUB VSUB sky130_fd_pr__nfet_g5v0d10v5 L=2 W=4 AS=2.4 AD=2.4 PS=9.2
+ PD=9.2
M$2 out \$2 VSUB VSUB sky130_fd_pr__nfet_g5v0d10v5 L=2 W=4 AS=2.4 AD=2.4 PS=9.2
+ PD=9.2
M$3 \$2 inp \$5 vdd sky130_fd_pr__pfet_g5v0d10v5 L=2 W=32 AS=19.2 AD=19.2
+ PS=65.2 PD=65.2
M$4 out inn \$5 vdd sky130_fd_pr__pfet_g5v0d10v5 L=2 W=32 AS=19.2 AD=19.2
+ PS=65.2 PD=65.2
M$5 \$5 pbias vdd vdd sky130_fd_pr__pfet_g5v0d10v5 L=8 W=32 AS=19.2 AD=19.2
+ PS=65.2 PD=65.2
.ENDS ota1b
