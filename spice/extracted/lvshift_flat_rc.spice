* NGSPICE file created from lvshift.ext - technology: sky130A

.subckt lvshift
X0 a_260_3200.t1 a_120_180.t2 vddh.t21 vddh.t20 sky130_fd_pr__pfet_g5v0d10v5 ad=0.35 pd=2.4 as=0.175 ps=1.2 w=0.5 l=0.5
X1 vss.t19 a_3240_3400.t2 x_sclk.t0 vss.t18 sky130_fd_pr__nfet_g5v0d10v5 ad=1.4 pd=5.4 as=1.4 ps=5.4 w=2 l=0.5
X2 vss.t15 a_sdata a_500_120.t1 vss.t14 sky130_fd_pr__nfet_g5v0d10v5 ad=0.35 pd=1.7 as=0.7 ps=3.4 w=1 l=0.5
X3 x_sout.t1 a_7440_3520.t2 vss.t27 vss.t26 sky130_fd_pr__nfet_g5v0d10v5 ad=0.7 pd=3.4 as=0.35 ps=1.7 w=1 l=0.5
X4 a_840_3400.t1 a_260_3200.t2 vss.t25 vss.t24 sky130_fd_pr__nfet_g5v0d10v5 ad=0.7 pd=3.4 as=0.35 ps=1.7 w=1 l=0.5
X5 a_5640_3400.t1 a_5060_3200.t2 vss.t3 vss.t2 sky130_fd_pr__nfet_g5v0d10v5 ad=0.7 pd=3.4 as=0.35 ps=1.7 w=1 l=0.5
X6 a_2660_3200.t0 a_2900_120.t2 vss.t1 vss.t0 sky130_fd_pr__nfet_g5v0d10v5 ad=4.2 pd=13.4 as=2.1 ps=6.7 w=6 l=0.5
X7 vddl.t1 a_rstn a_5300_120.t0 vddl.t0 sky130_fd_pr__pfet_g5v0d10v5 ad=1.4 pd=5.4 as=1.4 ps=5.4 w=2 l=0.5
X8 a_5060_3200.t0 a_5300_120.t2 vss.t29 vss.t28 sky130_fd_pr__nfet_g5v0d10v5 ad=4.2 pd=13.4 as=2.1 ps=6.7 w=6 l=0.5
X9 vddh.t3 a_5060_3200.t3 a_5640_3400.t0 vddh.t2 sky130_fd_pr__pfet_g5v0d10v5 ad=0.7 pd=2.7 as=1.4 ps=5.4 w=2 l=0.5
X10 vss.t31 a_5640_3400.t2 x_rstn.t1 vss.t30 sky130_fd_pr__nfet_g5v0d10v5 ad=1.4 pd=5.4 as=1.4 ps=5.4 w=2 l=0.5
X11 vddl.t3 a_sclk a_2900_120.t1 vddl.t2 sky130_fd_pr__pfet_g5v0d10v5 ad=1.4 pd=5.4 as=1.4 ps=5.4 w=2 l=0.5
X12 vddh.t9 a_2660_3200.t4 a_2520_180.t0 vddh.t8 sky130_fd_pr__pfet_g5v0d10v5 ad=0.175 pd=1.2 as=0.35 ps=2.4 w=0.5 l=0.5
X13 vddh.t7 a_2660_3200.t3 a_3240_3400.t0 vddh.t6 sky130_fd_pr__pfet_g5v0d10v5 ad=0.7 pd=2.7 as=1.4 ps=5.4 w=2 l=0.5
X14 a_2660_3200.t1 a_2520_180.t2 vddh.t19 vddh.t18 sky130_fd_pr__pfet_g5v0d10v5 ad=0.35 pd=2.4 as=0.175 ps=1.2 w=0.5 l=0.5
X15 x_sclk.t1 a_3240_3400.t3 vddh.t5 vddh.t4 sky130_fd_pr__pfet_g5v0d10v5 ad=1.4 pd=5.4 as=0.7 ps=2.7 w=2 l=0.5
X16 a_260_3200.t0 a_500_120.t2 vss.t5 vss.t4 sky130_fd_pr__nfet_g5v0d10v5 ad=4.2 pd=13.4 as=2.1 ps=6.7 w=6 l=0.5
X17 vss.t13 a_sclk a_2520_180.t1 vss.t12 sky130_fd_pr__nfet_g5v0d10v5 ad=2.1 pd=6.7 as=4.2 ps=13.4 w=6 l=0.5
X18 vddl.t5 a_sdata a_500_120.t0 vddl.t4 sky130_fd_pr__pfet_g5v0d10v5 ad=1.4 pd=5.4 as=1.4 ps=5.4 w=2 l=0.5
X19 vddh.t1 a_5060_3200.t4 a_4920_180.t0 vddh.t0 sky130_fd_pr__pfet_g5v0d10v5 ad=0.175 pd=1.2 as=0.35 ps=2.4 w=0.5 l=0.5
X20 vss.t7 a_rstn a_4920_180.t1 vss.t6 sky130_fd_pr__nfet_g5v0d10v5 ad=2.1 pd=6.7 as=4.2 ps=13.4 w=6 l=0.5
X21 vddh.t13 a_260_3200.t3 a_840_3400.t0 vddh.t12 sky130_fd_pr__pfet_g5v0d10v5 ad=0.7 pd=2.7 as=1.4 ps=5.4 w=2 l=0.5
X22 x_sdata.t1 a_840_3400.t3 vddh.t11 vddh.t10 sky130_fd_pr__pfet_g5v0d10v5 ad=1.4 pd=5.4 as=0.7 ps=2.7 w=2 l=0.5
X23 a_5060_3200.t1 a_4920_180.t2 vddh.t17 vddh.t16 sky130_fd_pr__pfet_g5v0d10v5 ad=0.35 pd=2.4 as=0.175 ps=1.2 w=0.5 l=0.5
X24 x_rstn.t0 a_5640_3400.t3 vddh.t23 vddh.t22 sky130_fd_pr__pfet_g5v0d10v5 ad=1.4 pd=5.4 as=0.7 ps=2.7 w=2 l=0.5
X25 vddl.t9 a_sout a_7440_3520.t0 vddl.t8 sky130_fd_pr__pfet_g5v0d10v5 ad=0.7 pd=2.7 as=1.4 ps=5.4 w=2 l=0.5
X26 vss.t9 a_rstn a_5300_120.t1 vss.t8 sky130_fd_pr__nfet_g5v0d10v5 ad=0.35 pd=1.7 as=0.7 ps=3.4 w=1 l=0.5
X27 x_sout.t0 a_7440_3520.t3 vddl.t7 vddl.t6 sky130_fd_pr__pfet_g5v0d10v5 ad=1.4 pd=5.4 as=0.7 ps=2.7 w=2 l=0.5
X28 vss.t33 a_sout a_7440_3520.t1 vss.t32 sky130_fd_pr__nfet_g5v0d10v5 ad=0.35 pd=1.7 as=0.7 ps=3.4 w=1 l=0.5
X29 vss.t11 a_sclk a_2900_120.t0 vss.t10 sky130_fd_pr__nfet_g5v0d10v5 ad=0.35 pd=1.7 as=0.7 ps=3.4 w=1 l=0.5
X30 vss.t17 a_sdata a_120_180.t1 vss.t16 sky130_fd_pr__nfet_g5v0d10v5 ad=2.1 pd=6.7 as=4.2 ps=13.4 w=6 l=0.5
X31 a_3240_3400.t1 a_2660_3200.t2 vss.t21 vss.t20 sky130_fd_pr__nfet_g5v0d10v5 ad=0.7 pd=3.4 as=0.35 ps=1.7 w=1 l=0.5
X32 vddh.t15 a_260_3200.t4 a_120_180.t0 vddh.t14 sky130_fd_pr__pfet_g5v0d10v5 ad=0.175 pd=1.2 as=0.35 ps=2.4 w=0.5 l=0.5
X33 vss.t23 a_840_3400.t2 x_sdata.t0 vss.t22 sky130_fd_pr__nfet_g5v0d10v5 ad=1.4 pd=5.4 as=1.4 ps=5.4 w=2 l=0.5
R0 x_sout.t1 x_sout 242.792
R1 x_sout x_sout.t0 248.871
R2 x_rstn.t0 x_rstn.n0 239.994
R3 x_rstn.n0 x_rstn.t1 94.9101
R4 x_rstn x_rstn.n0 0.453267
R5 a_4920_180.t0 a_4920_180.n0 736.119
R6 a_4920_180.n0 a_4920_180.t1 34.2216
R7 a_4920_180.n0 a_4920_180.t2 256.837
R8 x_sclk.t0 x_sclk.n0 94.9112
R9 x_sclk x_sclk.n0 0.453267
R10 x_sclk.n0 x_sclk.t1 239.993
R11 a_2520_180.t0 a_2520_180.n0 736.119
R12 a_2520_180.n0 a_2520_180.t1 34.2216
R13 a_2520_180.n0 a_2520_180.t2 256.837
R14 x_sdata.t0 x_sdata.n0 94.9112
R15 x_sdata x_sdata.n0 0.453267
R16 x_sdata.n0 x_sdata.t1 239.993
R17 a_120_180.t0 a_120_180.n0 736.119
R18 a_120_180.n0 a_120_180.t1 34.2216
R19 a_120_180.n0 a_120_180.t2 256.837
R20 a_7440_3520.t1 a_7440_3520.n1 246.077
R21 a_7440_3520.n1 a_7440_3520.t2 278.027
R22 a_7440_3520.n1 a_7440_3520.n0 1.2255
R23 a_7440_3520.n0 a_7440_3520.t3 325.502
R24 a_7440_3520.n0 a_7440_3520.t0 244.112
R25 a_5640_3400.t1 a_5640_3400.n0 238.701
R26 a_5640_3400.n0 a_5640_3400.n1 5.80309
R27 a_5640_3400.n1 a_5640_3400.t3 330.88
R28 a_5640_3400.n1 a_5640_3400.t0 243.028
R29 a_5640_3400.n0 a_5640_3400.t2 333.584
R30 a_5060_3200.t1 a_5060_3200.n2 735.91
R31 a_5060_3200.n2 a_5060_3200.n1 0.741533
R32 a_5060_3200.n1 a_5060_3200.t0 33.6889
R33 a_5060_3200.n1 a_5060_3200.t2 282.146
R34 a_5060_3200.n2 a_5060_3200.n0 0.161867
R35 a_5060_3200.n0 a_5060_3200.t3 329.147
R36 a_5060_3200.n0 a_5060_3200.t4 257.462
R37 a_3240_3400.t1 a_3240_3400.n0 238.701
R38 a_3240_3400.n0 a_3240_3400.n1 5.80309
R39 a_3240_3400.n1 a_3240_3400.t3 330.88
R40 a_3240_3400.n1 a_3240_3400.t0 243.028
R41 a_3240_3400.n0 a_3240_3400.t2 333.584
R42 a_2660_3200.t1 a_2660_3200.n2 735.91
R43 a_2660_3200.n2 a_2660_3200.n1 0.741533
R44 a_2660_3200.n1 a_2660_3200.t0 33.6889
R45 a_2660_3200.n1 a_2660_3200.t2 282.146
R46 a_2660_3200.n2 a_2660_3200.n0 0.161867
R47 a_2660_3200.n0 a_2660_3200.t3 329.147
R48 a_2660_3200.n0 a_2660_3200.t4 257.462
R49 a_840_3400.t1 a_840_3400.n0 238.701
R50 a_840_3400.n0 a_840_3400.n1 5.80309
R51 a_840_3400.n1 a_840_3400.t3 330.88
R52 a_840_3400.n1 a_840_3400.t0 243.028
R53 a_840_3400.n0 a_840_3400.t2 333.584
R54 a_260_3200.t1 a_260_3200.n2 735.91
R55 a_260_3200.n2 a_260_3200.n1 0.741533
R56 a_260_3200.n1 a_260_3200.t0 33.6889
R57 a_260_3200.n1 a_260_3200.t2 282.146
R58 a_260_3200.n2 a_260_3200.n0 0.161867
R59 a_260_3200.n0 a_260_3200.t3 329.147
R60 a_260_3200.n0 a_260_3200.t4 257.462
R61 a_5300_120.t1 a_5300_120.n0 242.111
R62 a_5300_120.n0 a_5300_120.t2 522.604
R63 a_5300_120.n0 a_5300_120.t0 240.942
R64 a_2900_120.t0 a_2900_120.n0 242.111
R65 a_2900_120.n0 a_2900_120.t2 522.604
R66 a_2900_120.n0 a_2900_120.t1 240.942
R67 a_500_120.t1 a_500_120.n0 242.111
R68 a_500_120.n0 a_500_120.t2 522.604
R69 a_500_120.n0 a_500_120.t0 240.942
R70 vddh.t1 vddh.n0 133.701
R71 vddh.n0 vddh.t17 133.701
R72 vddh.n14 vddh.n0 606.126
R73 vddh.n14 vddh.n1 1.11925
R74 vddh.n1 vddh.t22 1251.43
R75 vddh.t20 vddh.t14 407.144
R76 vddh.t12 vddh.t20 814.287
R77 vddh.t10 vddh.t12 407.144
R78 vddh.n3 vddh.t10 1079.74
R79 vddh.n3 vddh.t8 1317.24
R80 vddh.t8 vddh.t18 407.144
R81 vddh.t18 vddh.t6 814.287
R82 vddh.t4 vddh.t6 407.144
R83 vddh.n4 vddh.t4 1079.74
R84 vddh.n4 vddh.t0 1317.24
R85 vddh.t0 vddh.t16 407.144
R86 vddh.t16 vddh.t2 814.287
R87 vddh.t22 vddh.t2 407.144
R88 vddh.n13 vddh.n14 1.49425
R89 vddh.n5 vddh.n13 1.11925
R90 vddh vddh.n7 3.4105
R91 vddh.n7 vddh.n5 1.11925
R92 vddh.n7 vddh.n9 1.49425
R93 vddh.n9 vddh.n10 1.11925
R94 vddh.n10 vddh.n12 607.245
R95 vddh.n12 vddh.t15 133.701
R96 vddh.n12 vddh.t21 133.701
R97 vddh.n10 vddh.n11 209.846
R98 vddh.n11 vddh.t13 33.4255
R99 vddh.n11 vddh.t11 33.4255
R100 vddh vddh.n8 602.716
R101 vddh.n8 vddh.t9 133.701
R102 vddh.n8 vddh.t19 133.701
R103 vddh.n5 vddh.n6 209.846
R104 vddh.n6 vddh.t7 33.4255
R105 vddh.n6 vddh.t5 33.4255
R106 vddh.n13 vddh.n4 170.577
R107 vddh.n9 vddh.n3 170.577
R108 vddh.n1 vddh.n2 209.846
R109 vddh.n2 vddh.t3 33.4255
R110 vddh.n2 vddh.t23 33.4255
R111 vddl.t1 vddl.n208 243.266
R112 vddl.n208 vddl.n207 4.46612
R113 vddl.n207 vddl.n206 4.82967
R114 vddl.n195 vddl.n194 9.3005
R115 vddl.n197 vddl.n196 9.3005
R116 vddl.n192 vddl.n198 4.28224
R117 vddl.n206 vddl.n193 9.363
R118 vddl.n206 vddl.n195 0.09425
R119 vddl.n195 vddl.n197 0.15675
R120 vddl.n197 vddl.n192 2.68753
R121 vddl.n200 vddl.n199 34.6315
R122 vddl.n198 vddl.n200 185
R123 vddl.n202 vddl.n201 185
R124 vddl.n196 vddl.n202 185
R125 vddl.n204 vddl.n203 185
R126 vddl.n194 vddl.n204 185
R127 vddl.n193 vddl.n205 185
R128 vddl.n193 vddl.n194 16.0005
R129 vddl.n194 vddl.n196 16.0005
R130 vddl.n196 vddl.n198 16.0005
R131 vddl.n205 vddl.n204 114.001
R132 vddl.n204 vddl.n202 114.001
R133 vddl.n202 vddl.n200 114.001
R134 vddl.n199 vddl.n192 247.385
R135 vddl.n205 vddl.t8 222.5
R136 vddl.t8 vddl.n203 87.5005
R137 vddl.n203 vddl.n201 125.001
R138 vddl.n201 vddl.t6 87.5005
R139 vddl.n199 vddl.t6 131.672
R140 vddl.n207 vddl.n191 203.055
R141 vddl.n191 vddl.t9 33.4255
R142 vddl.n191 vddl.t7 33.4255
R143 vddl.n190 vddl.n0 4.5005
R144 vddl vddl.n190 3.4105
R145 vddl.n190 vddl.n208 3.74425
R146 vddl.n190 vddl.t5 247.007
R147 vddl vddl.t3 239.855
R148 vddl.n1 vddl.n2 4.28224
R149 vddl.n4 vddl.n3 9.3005
R150 vddl.n6 vddl.n5 9.3005
R151 vddl.n8 vddl.n7 9.3005
R152 vddl.n10 vddl.n9 9.3005
R153 vddl.n12 vddl.n11 9.3005
R154 vddl.n14 vddl.n13 9.3005
R155 vddl.n16 vddl.n15 9.3005
R156 vddl.n18 vddl.n17 9.3005
R157 vddl.n20 vddl.n19 9.3005
R158 vddl.n22 vddl.n21 9.3005
R159 vddl.n24 vddl.n23 9.3005
R160 vddl.n26 vddl.n25 9.3005
R161 vddl.n28 vddl.n27 9.3005
R162 vddl.n30 vddl.n29 9.3005
R163 vddl.n32 vddl.n31 9.3005
R164 vddl.n34 vddl.n33 9.3005
R165 vddl.n36 vddl.n35 9.3005
R166 vddl.n38 vddl.n37 9.3005
R167 vddl.n40 vddl.n39 9.3005
R168 vddl.n42 vddl.n41 9.3005
R169 vddl.n44 vddl.n43 9.3005
R170 vddl.n46 vddl.n45 9.3005
R171 vddl.n0 vddl.n47 9.3005
R172 vddl.n49 vddl.n48 9.3005
R173 vddl.n51 vddl.n50 9.3005
R174 vddl.n53 vddl.n52 9.3005
R175 vddl.n55 vddl.n54 9.3005
R176 vddl.n57 vddl.n56 9.3005
R177 vddl.n59 vddl.n58 9.3005
R178 vddl.n61 vddl.n60 9.3005
R179 vddl.n63 vddl.n62 9.3005
R180 vddl.n65 vddl.n64 9.3005
R181 vddl.n67 vddl.n66 9.3005
R182 vddl.n69 vddl.n68 9.3005
R183 vddl.n71 vddl.n70 9.3005
R184 vddl.n73 vddl.n72 9.3005
R185 vddl.n75 vddl.n74 9.3005
R186 vddl.n77 vddl.n76 9.3005
R187 vddl.n79 vddl.n78 9.3005
R188 vddl.n81 vddl.n80 9.3005
R189 vddl.n83 vddl.n82 9.3005
R190 vddl.n85 vddl.n84 9.3005
R191 vddl.n87 vddl.n86 9.3005
R192 vddl.n89 vddl.n88 9.3005
R193 vddl.n91 vddl.n90 9.3005
R194 vddl.n93 vddl.n92 4.28224
R195 vddl.n4 vddl.n1 2.68753
R196 vddl.n6 vddl.n4 0.15675
R197 vddl.n8 vddl.n6 0.15675
R198 vddl.n10 vddl.n8 0.15675
R199 vddl.n12 vddl.n10 0.15675
R200 vddl.n14 vddl.n12 0.15675
R201 vddl.n16 vddl.n14 0.15675
R202 vddl.n18 vddl.n16 0.15675
R203 vddl.n20 vddl.n18 0.15675
R204 vddl.n22 vddl.n20 0.15675
R205 vddl.n24 vddl.n22 0.15675
R206 vddl.n26 vddl.n24 0.15675
R207 vddl.n28 vddl.n26 0.15675
R208 vddl.n30 vddl.n28 0.15675
R209 vddl.n32 vddl.n30 0.15675
R210 vddl.n34 vddl.n32 0.15675
R211 vddl.n36 vddl.n34 0.15675
R212 vddl.n38 vddl.n36 0.15675
R213 vddl.n40 vddl.n38 0.15675
R214 vddl.n42 vddl.n40 0.15675
R215 vddl.n44 vddl.n42 0.15675
R216 vddl.n46 vddl.n44 0.15675
R217 vddl.n0 vddl.n46 0.15675
R218 vddl.n0 vddl.n49 0.15675
R219 vddl.n49 vddl.n51 0.15675
R220 vddl.n51 vddl.n53 0.15675
R221 vddl.n53 vddl.n55 0.15675
R222 vddl.n55 vddl.n57 0.15675
R223 vddl.n57 vddl.n59 0.15675
R224 vddl.n59 vddl.n61 0.15675
R225 vddl.n61 vddl.n63 0.15675
R226 vddl.n63 vddl.n65 0.15675
R227 vddl.n65 vddl.n67 0.15675
R228 vddl.n67 vddl.n69 0.15675
R229 vddl.n69 vddl.n71 0.15675
R230 vddl.n71 vddl.n73 0.15675
R231 vddl.n73 vddl.n75 0.15675
R232 vddl.n75 vddl.n77 0.15675
R233 vddl.n77 vddl.n79 0.15675
R234 vddl.n79 vddl.n81 0.15675
R235 vddl.n81 vddl.n83 0.15675
R236 vddl.n83 vddl.n85 0.15675
R237 vddl.n85 vddl.n87 0.15675
R238 vddl.n87 vddl.n89 0.15675
R239 vddl.n89 vddl.n91 0.15675
R240 vddl.n91 vddl.n93 2.68753
R241 vddl.n95 vddl.n94 185
R242 vddl.n97 vddl.n96 185
R243 vddl.n2 vddl.n97 185
R244 vddl.n99 vddl.n98 185
R245 vddl.n3 vddl.n99 185
R246 vddl.n101 vddl.n100 185
R247 vddl.n5 vddl.n101 185
R248 vddl.n103 vddl.n102 185
R249 vddl.n7 vddl.n103 185
R250 vddl.n105 vddl.n104 185
R251 vddl.n9 vddl.n105 185
R252 vddl.n107 vddl.n106 185
R253 vddl.n11 vddl.n107 185
R254 vddl.n109 vddl.n108 185
R255 vddl.n13 vddl.n109 185
R256 vddl.n111 vddl.n110 185
R257 vddl.n15 vddl.n111 185
R258 vddl.n113 vddl.n112 185
R259 vddl.n17 vddl.n113 185
R260 vddl.n115 vddl.n114 185
R261 vddl.n19 vddl.n115 185
R262 vddl.n117 vddl.n116 185
R263 vddl.n21 vddl.n117 185
R264 vddl.n119 vddl.n118 185
R265 vddl.n23 vddl.n119 185
R266 vddl.n121 vddl.n120 185
R267 vddl.n25 vddl.n121 185
R268 vddl.n123 vddl.n122 185
R269 vddl.n27 vddl.n123 185
R270 vddl.n125 vddl.n124 185
R271 vddl.n29 vddl.n125 185
R272 vddl.n127 vddl.n126 185
R273 vddl.n31 vddl.n127 185
R274 vddl.n129 vddl.n128 185
R275 vddl.n33 vddl.n129 185
R276 vddl.n131 vddl.n130 185
R277 vddl.n35 vddl.n131 185
R278 vddl.n133 vddl.n132 185
R279 vddl.n37 vddl.n133 185
R280 vddl.n135 vddl.n134 185
R281 vddl.n39 vddl.n135 185
R282 vddl.n137 vddl.n136 185
R283 vddl.n41 vddl.n137 185
R284 vddl.n139 vddl.n138 185
R285 vddl.n43 vddl.n139 185
R286 vddl.n141 vddl.n140 185
R287 vddl.n45 vddl.n141 185
R288 vddl.n143 vddl.n142 185
R289 vddl.n47 vddl.n143 185
R290 vddl.n145 vddl.n144 185
R291 vddl.n48 vddl.n145 185
R292 vddl.n147 vddl.n146 185
R293 vddl.n50 vddl.n147 185
R294 vddl.n149 vddl.n148 185
R295 vddl.n52 vddl.n149 185
R296 vddl.n151 vddl.n150 185
R297 vddl.n54 vddl.n151 185
R298 vddl.n153 vddl.n152 185
R299 vddl.n56 vddl.n153 185
R300 vddl.n155 vddl.n154 185
R301 vddl.n58 vddl.n155 185
R302 vddl.n157 vddl.n156 185
R303 vddl.n60 vddl.n157 185
R304 vddl.n159 vddl.n158 185
R305 vddl.n62 vddl.n159 185
R306 vddl.n161 vddl.n160 185
R307 vddl.n64 vddl.n161 185
R308 vddl.n163 vddl.n162 185
R309 vddl.n66 vddl.n163 185
R310 vddl.n165 vddl.n164 185
R311 vddl.n68 vddl.n165 185
R312 vddl.n167 vddl.n166 185
R313 vddl.n70 vddl.n167 185
R314 vddl.n169 vddl.n168 185
R315 vddl.n72 vddl.n169 185
R316 vddl.n171 vddl.n170 185
R317 vddl.n74 vddl.n171 185
R318 vddl.n173 vddl.n172 185
R319 vddl.n76 vddl.n173 185
R320 vddl.n175 vddl.n174 185
R321 vddl.n78 vddl.n175 185
R322 vddl.n177 vddl.n176 185
R323 vddl.n80 vddl.n177 185
R324 vddl.n179 vddl.n178 185
R325 vddl.n82 vddl.n179 185
R326 vddl.n181 vddl.n180 185
R327 vddl.n84 vddl.n181 185
R328 vddl.n183 vddl.n182 185
R329 vddl.n86 vddl.n183 185
R330 vddl.n185 vddl.n184 185
R331 vddl.n88 vddl.n185 185
R332 vddl.n187 vddl.n186 185
R333 vddl.n90 vddl.n187 185
R334 vddl.n92 vddl.n189 185
R335 vddl.n188 vddl.n93 245.095
R336 vddl.n1 vddl.n95 189.355
R337 vddl.n2 vddl.n3 16.0005
R338 vddl.n3 vddl.n5 16.0005
R339 vddl.n5 vddl.n7 16.0005
R340 vddl.n7 vddl.n9 16.0005
R341 vddl.n9 vddl.n11 16.0005
R342 vddl.n11 vddl.n13 16.0005
R343 vddl.n13 vddl.n15 16.0005
R344 vddl.n15 vddl.n17 16.0005
R345 vddl.n17 vddl.n19 16.0005
R346 vddl.n19 vddl.n21 16.0005
R347 vddl.n21 vddl.n23 16.0005
R348 vddl.n23 vddl.n25 16.0005
R349 vddl.n25 vddl.n27 16.0005
R350 vddl.n27 vddl.n29 16.0005
R351 vddl.n29 vddl.n31 16.0005
R352 vddl.n31 vddl.n33 16.0005
R353 vddl.n33 vddl.n35 16.0005
R354 vddl.n35 vddl.n37 16.0005
R355 vddl.n37 vddl.n39 16.0005
R356 vddl.n39 vddl.n41 16.0005
R357 vddl.n41 vddl.n43 16.0005
R358 vddl.n43 vddl.n45 16.0005
R359 vddl.n45 vddl.n47 16.0005
R360 vddl.n47 vddl.n48 16.0005
R361 vddl.n48 vddl.n50 16.0005
R362 vddl.n50 vddl.n52 16.0005
R363 vddl.n52 vddl.n54 16.0005
R364 vddl.n54 vddl.n56 16.0005
R365 vddl.n56 vddl.n58 16.0005
R366 vddl.n58 vddl.n60 16.0005
R367 vddl.n60 vddl.n62 16.0005
R368 vddl.n62 vddl.n64 16.0005
R369 vddl.n64 vddl.n66 16.0005
R370 vddl.n66 vddl.n68 16.0005
R371 vddl.n68 vddl.n70 16.0005
R372 vddl.n70 vddl.n72 16.0005
R373 vddl.n72 vddl.n74 16.0005
R374 vddl.n74 vddl.n76 16.0005
R375 vddl.n76 vddl.n78 16.0005
R376 vddl.n78 vddl.n80 16.0005
R377 vddl.n80 vddl.n82 16.0005
R378 vddl.n82 vddl.n84 16.0005
R379 vddl.n84 vddl.n86 16.0005
R380 vddl.n86 vddl.n88 16.0005
R381 vddl.n88 vddl.n90 16.0005
R382 vddl.n90 vddl.n92 16.0005
R383 vddl.n95 vddl.n97 114.001
R384 vddl.n97 vddl.n99 114.001
R385 vddl.n99 vddl.n101 114.001
R386 vddl.n101 vddl.n103 114.001
R387 vddl.n103 vddl.n105 114.001
R388 vddl.n105 vddl.n107 114.001
R389 vddl.n107 vddl.n109 114.001
R390 vddl.n109 vddl.n111 114.001
R391 vddl.n111 vddl.n113 114.001
R392 vddl.n113 vddl.n115 114.001
R393 vddl.n115 vddl.n117 114.001
R394 vddl.n117 vddl.n119 114.001
R395 vddl.n119 vddl.n121 114.001
R396 vddl.n121 vddl.n123 114.001
R397 vddl.n123 vddl.n125 114.001
R398 vddl.n125 vddl.n127 114.001
R399 vddl.n127 vddl.n129 114.001
R400 vddl.n129 vddl.n131 114.001
R401 vddl.n131 vddl.n133 114.001
R402 vddl.n133 vddl.n135 114.001
R403 vddl.n135 vddl.n137 114.001
R404 vddl.n137 vddl.n139 114.001
R405 vddl.n139 vddl.n141 114.001
R406 vddl.n141 vddl.n143 114.001
R407 vddl.n143 vddl.n145 114.001
R408 vddl.n145 vddl.n147 114.001
R409 vddl.n147 vddl.n149 114.001
R410 vddl.n149 vddl.n151 114.001
R411 vddl.n151 vddl.n153 114.001
R412 vddl.n153 vddl.n155 114.001
R413 vddl.n155 vddl.n157 114.001
R414 vddl.n157 vddl.n159 114.001
R415 vddl.n159 vddl.n161 114.001
R416 vddl.n161 vddl.n163 114.001
R417 vddl.n163 vddl.n165 114.001
R418 vddl.n165 vddl.n167 114.001
R419 vddl.n167 vddl.n169 114.001
R420 vddl.n169 vddl.n171 114.001
R421 vddl.n171 vddl.n173 114.001
R422 vddl.n173 vddl.n175 114.001
R423 vddl.n175 vddl.n177 114.001
R424 vddl.n177 vddl.n179 114.001
R425 vddl.n179 vddl.n181 114.001
R426 vddl.n181 vddl.n183 114.001
R427 vddl.n183 vddl.n185 114.001
R428 vddl.n185 vddl.n187 114.001
R429 vddl.n187 vddl.n189 114.001
R430 vddl.n189 vddl.n188 36.0484
R431 vddl.n94 vddl.t4 121.278
R432 vddl.n94 vddl.n96 101.064
R433 vddl.n96 vddl.n98 101.064
R434 vddl.n98 vddl.n100 101.064
R435 vddl.n100 vddl.n102 101.064
R436 vddl.n102 vddl.n104 101.064
R437 vddl.n104 vddl.n106 101.064
R438 vddl.n106 vddl.n108 101.064
R439 vddl.n108 vddl.n110 101.064
R440 vddl.n110 vddl.n112 101.064
R441 vddl.n112 vddl.n114 101.064
R442 vddl.n114 vddl.n116 101.064
R443 vddl.n116 vddl.n118 101.064
R444 vddl.n118 vddl.n120 101.064
R445 vddl.n120 vddl.n122 101.064
R446 vddl.n122 vddl.n124 101.064
R447 vddl.n124 vddl.n126 101.064
R448 vddl.n126 vddl.n128 101.064
R449 vddl.n128 vddl.n130 101.064
R450 vddl.n130 vddl.n132 101.064
R451 vddl.n132 vddl.n134 101.064
R452 vddl.n134 vddl.n136 101.064
R453 vddl.n136 vddl.n138 101.064
R454 vddl.n138 vddl.t2 80.8516
R455 vddl.n140 vddl.t2 20.2133
R456 vddl.n140 vddl.n142 101.064
R457 vddl.n142 vddl.n144 101.064
R458 vddl.n144 vddl.n146 101.064
R459 vddl.n146 vddl.n148 101.064
R460 vddl.n148 vddl.n150 101.064
R461 vddl.n150 vddl.n152 101.064
R462 vddl.n152 vddl.n154 101.064
R463 vddl.n154 vddl.n156 101.064
R464 vddl.n156 vddl.n158 101.064
R465 vddl.n158 vddl.n160 101.064
R466 vddl.n160 vddl.n162 101.064
R467 vddl.n162 vddl.n164 101.064
R468 vddl.n164 vddl.n166 101.064
R469 vddl.n166 vddl.n168 101.064
R470 vddl.n168 vddl.n170 101.064
R471 vddl.n170 vddl.n172 101.064
R472 vddl.n172 vddl.n174 101.064
R473 vddl.n174 vddl.n176 101.064
R474 vddl.n176 vddl.n178 101.064
R475 vddl.n178 vddl.n180 101.064
R476 vddl.n180 vddl.n182 101.064
R477 vddl.n182 vddl.n184 101.064
R478 vddl.n184 vddl.n186 101.064
R479 vddl.n186 vddl.t0 80.8516
R480 vddl.n188 vddl.t0 110.668
R481 vss.n0 vss.t9 39.9005
R482 vss.n0 vss.t3 39.9005
R483 vss.n2 vss.n0 211.946
R484 vss.n3 vss.n2 4.0732
R485 vss.n3 vss.n4 4.5005
R486 vss.n6 vss.n5 4.5005
R487 vss.n3 vss.n6 1.05867
R488 vss.n6 vss.n7 1.02666
R489 vss.n296 vss.n7 4.61955
R490 vss.n7 vss.t31 96.7534
R491 vss.n9 vss.n10 4.28224
R492 vss.n12 vss.n11 9.3005
R493 vss.n14 vss.n13 9.3005
R494 vss.n16 vss.n15 9.3005
R495 vss.n18 vss.n17 9.3005
R496 vss.n20 vss.n19 9.3005
R497 vss.n22 vss.n21 9.3005
R498 vss.n24 vss.n23 9.3005
R499 vss.n26 vss.n25 9.3005
R500 vss.n28 vss.n27 9.3005
R501 vss.n30 vss.n29 9.3005
R502 vss.n32 vss.n31 9.3005
R503 vss.n34 vss.n33 9.3005
R504 vss.n36 vss.n35 9.3005
R505 vss.n38 vss.n37 9.3005
R506 vss.n40 vss.n39 9.3005
R507 vss.n42 vss.n41 9.3005
R508 vss.n44 vss.n43 9.3005
R509 vss.n46 vss.n45 9.3005
R510 vss.n48 vss.n47 9.3005
R511 vss.n50 vss.n49 9.3005
R512 vss.n52 vss.n51 9.3005
R513 vss.n54 vss.n53 9.3005
R514 vss.n56 vss.n55 9.3005
R515 vss.n58 vss.n57 9.3005
R516 vss.n60 vss.n59 9.3005
R517 vss.n62 vss.n61 9.3005
R518 vss.n64 vss.n63 9.3005
R519 vss.n66 vss.n65 9.3005
R520 vss.n68 vss.n67 9.3005
R521 vss.n70 vss.n69 9.3005
R522 vss.n72 vss.n71 9.3005
R523 vss.n74 vss.n73 9.3005
R524 vss.n76 vss.n75 9.3005
R525 vss.n78 vss.n77 9.3005
R526 vss.n80 vss.n79 9.3005
R527 vss.n82 vss.n81 9.3005
R528 vss.n84 vss.n83 9.3005
R529 vss.n86 vss.n85 9.3005
R530 vss.n88 vss.n87 9.3005
R531 vss.n90 vss.n89 9.3005
R532 vss.n92 vss.n91 9.3005
R533 vss.n94 vss.n93 9.3005
R534 vss.n96 vss.n95 9.3005
R535 vss.n98 vss.n97 9.3005
R536 vss.n100 vss.n99 9.3005
R537 vss.n102 vss.n101 9.3005
R538 vss.n104 vss.n103 9.3005
R539 vss.n106 vss.n105 9.3005
R540 vss.n108 vss.n107 9.3005
R541 vss.n110 vss.n109 9.3005
R542 vss.n112 vss.n111 9.3005
R543 vss.n114 vss.n113 9.3005
R544 vss.n116 vss.n115 9.3005
R545 vss.n118 vss.n117 9.3005
R546 vss.n120 vss.n119 9.3005
R547 vss.n122 vss.n121 9.3005
R548 vss.n124 vss.n123 9.3005
R549 vss.n126 vss.n125 9.3005
R550 vss.n128 vss.n127 9.3005
R551 vss.n130 vss.n129 9.3005
R552 vss.n132 vss.n131 9.3005
R553 vss.n134 vss.n133 9.3005
R554 vss.n136 vss.n135 9.3005
R555 vss.n138 vss.n137 9.3005
R556 vss.n8 vss.n139 4.28224
R557 vss.n279 vss.n278 4.5005
R558 vss.n281 vss.n280 4.5005
R559 vss.n283 vss.n282 4.5005
R560 vss.n285 vss.n284 4.5005
R561 vss.n287 vss.n286 4.5005
R562 vss.n12 vss.n9 2.68753
R563 vss.n288 vss.n12 0.016125
R564 vss.n288 vss.n14 0.141125
R565 vss.n14 vss.n16 0.15675
R566 vss.n16 vss.n18 0.15675
R567 vss.n18 vss.n20 0.15675
R568 vss.n20 vss.n22 0.15675
R569 vss.n22 vss.n24 0.15675
R570 vss.n24 vss.n26 0.15675
R571 vss.n286 vss.n26 0.047375
R572 vss.n286 vss.n28 0.109875
R573 vss.n28 vss.n30 0.15675
R574 vss.n30 vss.n32 0.15675
R575 vss.n32 vss.n34 0.15675
R576 vss.n34 vss.n36 0.15675
R577 vss.n36 vss.n38 0.15675
R578 vss.n38 vss.n40 0.15675
R579 vss.n40 vss.n284 0.078625
R580 vss.n284 vss.n42 0.078625
R581 vss.n42 vss.n44 0.15675
R582 vss.n44 vss.n46 0.15675
R583 vss.n46 vss.n48 0.15675
R584 vss.n48 vss.n50 0.15675
R585 vss.n50 vss.n52 0.15675
R586 vss.n52 vss.n54 0.15675
R587 vss.n54 vss.n56 0.15675
R588 vss.n56 vss.n58 0.15675
R589 vss.n58 vss.n60 0.15675
R590 vss.n282 vss.n60 0.016125
R591 vss.n282 vss.n62 0.141125
R592 vss.n62 vss.n64 0.15675
R593 vss.n64 vss.n66 0.15675
R594 vss.n66 vss.n68 0.15675
R595 vss.n68 vss.n70 0.15675
R596 vss.n70 vss.n72 0.15675
R597 vss.n72 vss.n74 0.15675
R598 vss.n74 vss.n280 0.047375
R599 vss.n280 vss.n76 0.109875
R600 vss.n76 vss.n78 0.15675
R601 vss.n78 vss.n80 0.15675
R602 vss.n80 vss.n82 0.15675
R603 vss.n82 vss.n84 0.15675
R604 vss.n84 vss.n86 0.15675
R605 vss.n86 vss.n88 0.15675
R606 vss.n88 vss.n278 0.078625
R607 vss.n278 vss.n90 0.078625
R608 vss.n90 vss.n92 0.15675
R609 vss.n92 vss.n94 0.15675
R610 vss.n94 vss.n96 0.15675
R611 vss.n96 vss.n98 0.15675
R612 vss.n98 vss.n100 0.15675
R613 vss.n100 vss.n102 0.15675
R614 vss.n102 vss.n104 0.15675
R615 vss.n104 vss.n106 0.15675
R616 vss.n106 vss.n108 0.15675
R617 vss.n4 vss.n108 0.016125
R618 vss.n4 vss.n110 0.141125
R619 vss.n110 vss.n112 0.15675
R620 vss.n112 vss.n114 0.15675
R621 vss.n114 vss.n116 0.15675
R622 vss.n116 vss.n118 0.15675
R623 vss.n118 vss.n120 0.15675
R624 vss.n120 vss.n122 0.15675
R625 vss.n122 vss.n5 0.047375
R626 vss.n5 vss.n124 0.109875
R627 vss.n124 vss.n126 0.15675
R628 vss.n126 vss.n128 0.15675
R629 vss.n128 vss.n130 0.15675
R630 vss.n130 vss.n132 0.15675
R631 vss.n132 vss.n134 0.15675
R632 vss.n134 vss.n136 0.15675
R633 vss.n136 vss.n296 0.078625
R634 vss.n296 vss.n138 0.078625
R635 vss.n138 vss.n8 2.68753
R636 vss vss.n292 3.4105
R637 vss.n292 vss.n288 4.61955
R638 vss vss.n294 0.6632
R639 vss.n294 vss.n295 211.946
R640 vss.n295 vss.t15 39.9005
R641 vss.n295 vss.t25 39.9005
R642 vss.n294 vss.n293 25.7261
R643 vss.n293 vss.t17 6.6505
R644 vss.n293 vss.t5 6.6505
R645 vss.n292 vss.n287 1.02666
R646 vss.n287 vss.n285 1.05867
R647 vss.n285 vss.n283 1.43327
R648 vss.n283 vss.n281 1.05867
R649 vss.n281 vss.n279 1.05867
R650 vss.n279 vss.n3 1.43327
R651 vss.n279 vss.t19 96.7534
R652 vss.n283 vss.n290 4.0732
R653 vss.n290 vss.n291 211.946
R654 vss.n291 vss.t11 39.9005
R655 vss.n291 vss.t21 39.9005
R656 vss.n290 vss.n289 25.7261
R657 vss.n289 vss.t13 6.6505
R658 vss.n289 vss.t1 6.6505
R659 vss.n285 vss.t23 96.7534
R660 vss.n141 vss.n140 585
R661 vss.n8 vss.n141 589.355
R662 vss.n143 vss.n142 585
R663 vss.n139 vss.n143 585
R664 vss.n145 vss.n144 585
R665 vss.n137 vss.n145 585
R666 vss.n147 vss.n146 585
R667 vss.n135 vss.n147 585
R668 vss.n149 vss.n148 585
R669 vss.n133 vss.n149 585
R670 vss.n151 vss.n150 585
R671 vss.n131 vss.n151 585
R672 vss.n153 vss.n152 585
R673 vss.n129 vss.n153 585
R674 vss.n155 vss.n154 585
R675 vss.n127 vss.n155 585
R676 vss.n157 vss.n156 585
R677 vss.n125 vss.n157 585
R678 vss.n159 vss.n158 585
R679 vss.n123 vss.n159 585
R680 vss.n161 vss.n160 585
R681 vss.n121 vss.n161 585
R682 vss.n163 vss.n162 585
R683 vss.n119 vss.n163 585
R684 vss.n165 vss.n164 585
R685 vss.n117 vss.n165 585
R686 vss.n167 vss.n166 585
R687 vss.n115 vss.n167 585
R688 vss.n169 vss.n168 585
R689 vss.n113 vss.n169 585
R690 vss.n171 vss.n170 585
R691 vss.n111 vss.n171 585
R692 vss.n173 vss.n172 585
R693 vss.n109 vss.n173 585
R694 vss.n175 vss.n174 585
R695 vss.n107 vss.n175 585
R696 vss.n177 vss.n176 585
R697 vss.n105 vss.n177 585
R698 vss.n179 vss.n178 585
R699 vss.n103 vss.n179 585
R700 vss.n181 vss.n180 585
R701 vss.n101 vss.n181 585
R702 vss.n183 vss.n182 585
R703 vss.n99 vss.n183 585
R704 vss.n185 vss.n184 585
R705 vss.n97 vss.n185 585
R706 vss.n187 vss.n186 585
R707 vss.n95 vss.n187 585
R708 vss.n189 vss.n188 585
R709 vss.n93 vss.n189 585
R710 vss.n191 vss.n190 585
R711 vss.n91 vss.n191 585
R712 vss.n193 vss.n192 585
R713 vss.n89 vss.n193 585
R714 vss.n195 vss.n194 585
R715 vss.n87 vss.n195 585
R716 vss.n197 vss.n196 585
R717 vss.n85 vss.n197 585
R718 vss.n199 vss.n198 585
R719 vss.n83 vss.n199 585
R720 vss.n201 vss.n200 585
R721 vss.n81 vss.n201 585
R722 vss.n203 vss.n202 585
R723 vss.n79 vss.n203 585
R724 vss.n205 vss.n204 585
R725 vss.n77 vss.n205 585
R726 vss.n207 vss.n206 585
R727 vss.n75 vss.n207 585
R728 vss.n209 vss.n208 585
R729 vss.n73 vss.n209 585
R730 vss.n211 vss.n210 585
R731 vss.n71 vss.n211 585
R732 vss.n213 vss.n212 585
R733 vss.n69 vss.n213 585
R734 vss.n215 vss.n214 585
R735 vss.n67 vss.n215 585
R736 vss.n217 vss.n216 585
R737 vss.n65 vss.n217 585
R738 vss.n219 vss.n218 585
R739 vss.n63 vss.n219 585
R740 vss.n221 vss.n220 585
R741 vss.n61 vss.n221 585
R742 vss.n223 vss.n222 585
R743 vss.n59 vss.n223 585
R744 vss.n225 vss.n224 585
R745 vss.n57 vss.n225 585
R746 vss.n227 vss.n226 585
R747 vss.n55 vss.n227 585
R748 vss.n229 vss.n228 585
R749 vss.n53 vss.n229 585
R750 vss.n231 vss.n230 585
R751 vss.n51 vss.n231 585
R752 vss.n233 vss.n232 585
R753 vss.n49 vss.n233 585
R754 vss.n235 vss.n234 585
R755 vss.n47 vss.n235 585
R756 vss.n237 vss.n236 585
R757 vss.n45 vss.n237 585
R758 vss.n239 vss.n238 585
R759 vss.n43 vss.n239 585
R760 vss.n241 vss.n240 585
R761 vss.n41 vss.n241 585
R762 vss.n243 vss.n242 585
R763 vss.n39 vss.n243 585
R764 vss.n245 vss.n244 585
R765 vss.n37 vss.n245 585
R766 vss.n247 vss.n246 585
R767 vss.n35 vss.n247 585
R768 vss.n249 vss.n248 585
R769 vss.n33 vss.n249 585
R770 vss.n251 vss.n250 585
R771 vss.n31 vss.n251 585
R772 vss.n253 vss.n252 585
R773 vss.n29 vss.n253 585
R774 vss.n255 vss.n254 585
R775 vss.n27 vss.n255 585
R776 vss.n257 vss.n256 585
R777 vss.n25 vss.n257 585
R778 vss.n259 vss.n258 585
R779 vss.n23 vss.n259 585
R780 vss.n261 vss.n260 585
R781 vss.n21 vss.n261 585
R782 vss.n263 vss.n262 585
R783 vss.n19 vss.n263 585
R784 vss.n265 vss.n264 585
R785 vss.n17 vss.n265 585
R786 vss.n267 vss.n266 585
R787 vss.n15 vss.n267 585
R788 vss.n269 vss.n268 585
R789 vss.n13 vss.n269 585
R790 vss.n271 vss.n270 585
R791 vss.n11 vss.n271 585
R792 vss.n273 vss.n272 585
R793 vss.n10 vss.n273 585
R794 vss.n9 vss.n277 589.355
R795 vss.n10 vss.n11 16.0005
R796 vss.n11 vss.n13 16.0005
R797 vss.n13 vss.n15 16.0005
R798 vss.n15 vss.n17 16.0005
R799 vss.n17 vss.n19 16.0005
R800 vss.n19 vss.n21 16.0005
R801 vss.n21 vss.n23 16.0005
R802 vss.n23 vss.n25 16.0005
R803 vss.n25 vss.n27 16.0005
R804 vss.n27 vss.n29 16.0005
R805 vss.n29 vss.n31 16.0005
R806 vss.n31 vss.n33 16.0005
R807 vss.n33 vss.n35 16.0005
R808 vss.n35 vss.n37 16.0005
R809 vss.n37 vss.n39 16.0005
R810 vss.n39 vss.n41 16.0005
R811 vss.n41 vss.n43 16.0005
R812 vss.n43 vss.n45 16.0005
R813 vss.n45 vss.n47 16.0005
R814 vss.n47 vss.n49 16.0005
R815 vss.n49 vss.n51 16.0005
R816 vss.n51 vss.n53 16.0005
R817 vss.n53 vss.n55 16.0005
R818 vss.n55 vss.n57 16.0005
R819 vss.n57 vss.n59 16.0005
R820 vss.n59 vss.n61 16.0005
R821 vss.n61 vss.n63 16.0005
R822 vss.n63 vss.n65 16.0005
R823 vss.n65 vss.n67 16.0005
R824 vss.n67 vss.n69 16.0005
R825 vss.n69 vss.n71 16.0005
R826 vss.n71 vss.n73 16.0005
R827 vss.n73 vss.n75 16.0005
R828 vss.n75 vss.n77 16.0005
R829 vss.n77 vss.n79 16.0005
R830 vss.n79 vss.n81 16.0005
R831 vss.n81 vss.n83 16.0005
R832 vss.n83 vss.n85 16.0005
R833 vss.n85 vss.n87 16.0005
R834 vss.n87 vss.n89 16.0005
R835 vss.n89 vss.n91 16.0005
R836 vss.n91 vss.n93 16.0005
R837 vss.n93 vss.n95 16.0005
R838 vss.n95 vss.n97 16.0005
R839 vss.n97 vss.n99 16.0005
R840 vss.n99 vss.n101 16.0005
R841 vss.n101 vss.n103 16.0005
R842 vss.n103 vss.n105 16.0005
R843 vss.n105 vss.n107 16.0005
R844 vss.n107 vss.n109 16.0005
R845 vss.n109 vss.n111 16.0005
R846 vss.n111 vss.n113 16.0005
R847 vss.n113 vss.n115 16.0005
R848 vss.n115 vss.n117 16.0005
R849 vss.n117 vss.n119 16.0005
R850 vss.n119 vss.n121 16.0005
R851 vss.n121 vss.n123 16.0005
R852 vss.n123 vss.n125 16.0005
R853 vss.n125 vss.n127 16.0005
R854 vss.n127 vss.n129 16.0005
R855 vss.n129 vss.n131 16.0005
R856 vss.n131 vss.n133 16.0005
R857 vss.n133 vss.n135 16.0005
R858 vss.n135 vss.n137 16.0005
R859 vss.n137 vss.n139 16.0005
R860 vss.n277 vss.n273 191
R861 vss.n273 vss.n271 191
R862 vss.n271 vss.n269 191
R863 vss.n269 vss.n267 191
R864 vss.n267 vss.n265 191
R865 vss.n265 vss.n263 191
R866 vss.n263 vss.n261 191
R867 vss.n261 vss.n259 191
R868 vss.n259 vss.n257 191
R869 vss.n257 vss.n255 191
R870 vss.n255 vss.n253 191
R871 vss.n253 vss.n251 191
R872 vss.n251 vss.n249 191
R873 vss.n249 vss.n247 191
R874 vss.n247 vss.n245 191
R875 vss.n245 vss.n243 191
R876 vss.n243 vss.n241 191
R877 vss.n241 vss.n239 191
R878 vss.n239 vss.n237 191
R879 vss.n237 vss.n235 191
R880 vss.n235 vss.n233 191
R881 vss.n233 vss.n231 191
R882 vss.n231 vss.n229 191
R883 vss.n229 vss.n227 191
R884 vss.n227 vss.n225 191
R885 vss.n225 vss.n223 191
R886 vss.n223 vss.n221 191
R887 vss.n221 vss.n219 191
R888 vss.n219 vss.n217 191
R889 vss.n217 vss.n215 191
R890 vss.n215 vss.n213 191
R891 vss.n213 vss.n211 191
R892 vss.n211 vss.n209 191
R893 vss.n209 vss.n207 191
R894 vss.n207 vss.n205 191
R895 vss.n205 vss.n203 191
R896 vss.n203 vss.n201 191
R897 vss.n201 vss.n199 191
R898 vss.n199 vss.n197 191
R899 vss.n197 vss.n195 191
R900 vss.n195 vss.n193 191
R901 vss.n193 vss.n191 191
R902 vss.n191 vss.n189 191
R903 vss.n189 vss.n187 191
R904 vss.n187 vss.n185 191
R905 vss.n185 vss.n183 191
R906 vss.n183 vss.n181 191
R907 vss.n181 vss.n179 191
R908 vss.n179 vss.n177 191
R909 vss.n177 vss.n175 191
R910 vss.n175 vss.n173 191
R911 vss.n173 vss.n171 191
R912 vss.n171 vss.n169 191
R913 vss.n169 vss.n167 191
R914 vss.n167 vss.n165 191
R915 vss.n165 vss.n163 191
R916 vss.n163 vss.n161 191
R917 vss.n161 vss.n159 191
R918 vss.n159 vss.n157 191
R919 vss.n157 vss.n155 191
R920 vss.n155 vss.n153 191
R921 vss.n153 vss.n151 191
R922 vss.n151 vss.n149 191
R923 vss.n149 vss.n147 191
R924 vss.n147 vss.n145 191
R925 vss.n145 vss.n143 191
R926 vss.n143 vss.n141 191
R927 vss.n277 vss.t16 696.049
R928 vss.n272 vss.t16 12.3393
R929 vss.n272 vss.n270 123.388
R930 vss.n270 vss.n268 123.388
R931 vss.n268 vss.t4 37.0168
R932 vss.t4 vss.n266 86.3718
R933 vss.n266 vss.n264 123.388
R934 vss.n264 vss.n262 123.388
R935 vss.n262 vss.n260 123.388
R936 vss.n260 vss.n258 123.388
R937 vss.n258 vss.t14 12.3393
R938 vss.t14 vss.n256 111.049
R939 vss.n256 vss.n254 123.388
R940 vss.n254 vss.t24 61.6943
R941 vss.t24 vss.n252 61.6943
R942 vss.n252 vss.n250 123.388
R943 vss.n250 vss.n248 123.388
R944 vss.n248 vss.n246 123.388
R945 vss.n246 vss.n244 123.388
R946 vss.n244 vss.t22 37.0168
R947 vss.t22 vss.n242 86.3718
R948 vss.n242 vss.n240 123.388
R949 vss.n240 vss.n238 123.388
R950 vss.n238 vss.n236 123.388
R951 vss.n236 vss.n234 123.388
R952 vss.n234 vss.n232 123.388
R953 vss.n232 vss.n230 123.388
R954 vss.n230 vss.n228 123.388
R955 vss.n228 vss.n226 123.388
R956 vss.n226 vss.t12 111.049
R957 vss.n224 vss.t12 12.3393
R958 vss.n224 vss.n222 123.388
R959 vss.n222 vss.n220 123.388
R960 vss.n220 vss.t0 37.0168
R961 vss.t0 vss.n218 86.3718
R962 vss.n218 vss.n216 123.388
R963 vss.n216 vss.n214 123.388
R964 vss.n214 vss.n212 123.388
R965 vss.n212 vss.n210 123.388
R966 vss.n210 vss.t10 12.3393
R967 vss.t10 vss.n208 111.049
R968 vss.n208 vss.n206 123.388
R969 vss.n206 vss.t20 61.6943
R970 vss.t20 vss.n204 61.6943
R971 vss.n204 vss.n202 123.388
R972 vss.n202 vss.n200 123.388
R973 vss.n200 vss.n198 123.388
R974 vss.n198 vss.n196 123.388
R975 vss.n196 vss.t18 37.0168
R976 vss.t18 vss.n194 86.3718
R977 vss.n194 vss.n192 123.388
R978 vss.n192 vss.n190 123.388
R979 vss.n190 vss.n188 123.388
R980 vss.n188 vss.n186 123.388
R981 vss.n186 vss.n184 123.388
R982 vss.n184 vss.n182 123.388
R983 vss.n182 vss.n180 123.388
R984 vss.n180 vss.n178 123.388
R985 vss.n178 vss.t6 111.049
R986 vss.n176 vss.t6 12.3393
R987 vss.n176 vss.n174 123.388
R988 vss.n174 vss.n172 123.388
R989 vss.n172 vss.t28 37.0168
R990 vss.t28 vss.n170 86.3718
R991 vss.n170 vss.n168 123.388
R992 vss.n168 vss.n166 123.388
R993 vss.n166 vss.n164 123.388
R994 vss.n164 vss.n162 123.388
R995 vss.n162 vss.t8 12.3393
R996 vss.t8 vss.n160 111.049
R997 vss.n160 vss.n158 123.388
R998 vss.n158 vss.t2 61.6943
R999 vss.t2 vss.n156 61.6943
R1000 vss.n156 vss.n154 123.388
R1001 vss.n154 vss.n152 123.388
R1002 vss.n152 vss.n150 123.388
R1003 vss.n150 vss.n148 123.388
R1004 vss.n148 vss.t30 37.0168
R1005 vss.t30 vss.n146 86.3718
R1006 vss.n146 vss.n144 123.388
R1007 vss.n144 vss.n142 123.388
R1008 vss.n142 vss.n140 123.388
R1009 vss.n140 vss.n276 1669.43
R1010 vss.n276 vss.n274 22733.3
R1011 vss.n276 vss.t32 52860.8
R1012 vss.t26 vss.t32 577.049
R1013 vss.n274 vss.t26 151.476
R1014 vss.n274 vss.n275 1897.13
R1015 vss.n275 vss.t33 39.9005
R1016 vss.n275 vss.t27 39.9005
R1017 vss.n2 vss.n1 25.7261
R1018 vss.n1 vss.t7 6.6505
R1019 vss.n1 vss.t29 6.6505
C0 vddl vddh 0.88972f
C1 x_rstn vddh 0.79916f
C2 a_rstn vddl 1.30837f
C3 vddh x_sdata 0.8215f
C4 x_sclk vddh 0.82158f
C5 a_rstn x_rstn 0.42602f
C6 a_sclk a_sdata 0.01461f
C7 vddl a_sdata 1.34728f
C8 a_rstn vddh 0.34434f
C9 a_sout x_sout 0.23974f
C10 a_sdata x_sdata 0.41408f
C11 x_sout vddl 0.29189f
C12 vddh a_sdata 0.45847f
C13 a_sout vddl 0.38165f
C14 vddl a_sclk 1.41966f
C15 a_sclk x_sclk 0.41408f
C16 vddl x_sdata 0.02612f
C17 a_sout vddh 0.02425f
C18 vddl x_sclk 0.02612f
C19 a_sclk vddh 0.45847f
C20 a_rstn a_sclk 0.01674f
C21 x_sout vss 2.13572f
C22 x_rstn vss 0.99691f
C23 x_sclk vss 0.91017f
C24 x_sdata vss 0.91025f
C25 a_sout vss 0.97751f
C26 a_rstn vss 3.1426f
C27 a_sclk vss 2.24252f
C28 a_sdata vss 2.27699f
C29 vddh vss 13.04765f
C30 vddl vss 22.84291f
C31 vddl.t1 vss 0.04681f
C32 vddl.n1 vss 0.01205f
C33 vddl.n4 vss 0.02374f
C34 vddl.n91 vss 0.02374f
C35 vddl.n93 vss 0.03359f
C36 vddl.n94 vss 0.0896f
C37 vddl.n95 vss 0.01412f
C38 vddl.n96 vss 0.08146f
C39 vddl.n98 vss 0.08146f
C40 vddl.n100 vss 0.08146f
C41 vddl.n102 vss 0.08146f
C42 vddl.n104 vss 0.08146f
C43 vddl.n106 vss 0.08146f
C44 vddl.n108 vss 0.08146f
C45 vddl.n110 vss 0.08146f
C46 vddl.n112 vss 0.08146f
C47 vddl.n114 vss 0.08146f
C48 vddl.n116 vss 0.08146f
C49 vddl.n118 vss 0.08146f
C50 vddl.n120 vss 0.08146f
C51 vddl.n122 vss 0.08146f
C52 vddl.n124 vss 0.08146f
C53 vddl.n126 vss 0.08146f
C54 vddl.n128 vss 0.08146f
C55 vddl.n130 vss 0.08146f
C56 vddl.n132 vss 0.08146f
C57 vddl.n134 vss 0.08146f
C58 vddl.n136 vss 0.08146f
C59 vddl.n138 vss 0.07331f
C60 vddl.n140 vss 0.04888f
C61 vddl.n142 vss 0.08146f
C62 vddl.n144 vss 0.08146f
C63 vddl.n146 vss 0.08146f
C64 vddl.n148 vss 0.08146f
C65 vddl.n150 vss 0.08146f
C66 vddl.n152 vss 0.08146f
C67 vddl.n154 vss 0.08146f
C68 vddl.n156 vss 0.08146f
C69 vddl.n158 vss 0.08146f
C70 vddl.n160 vss 0.08146f
C71 vddl.n162 vss 0.08146f
C72 vddl.n164 vss 0.08146f
C73 vddl.n166 vss 0.08146f
C74 vddl.n168 vss 0.08146f
C75 vddl.n170 vss 0.08146f
C76 vddl.n172 vss 0.08146f
C77 vddl.n174 vss 0.08146f
C78 vddl.n176 vss 0.08146f
C79 vddl.n178 vss 0.08146f
C80 vddl.n180 vss 0.08146f
C81 vddl.n182 vss 0.08146f
C82 vddl.n184 vss 0.08146f
C83 vddl.n186 vss 0.07331f
C84 vddl.n188 vss 0.10903f
C85 vddl.t4 vss 0.85531f
C86 vddl.t2 vss 0.04073f
C87 vddl.t0 vss 0.20124f
C88 vddl.n190 vss 0.34003f
C89 vddl.t3 vss 0.04553f
C90 vddl.t5 vss 0.04948f
C91 vddl.n191 vss 0.02581f
C92 vddl.t9 vss 0.01213f
C93 vddl.t7 vss 0.01213f
C94 vddl.n192 vss 0.03188f
C95 vddl.n193 vss 0.01185f
C96 vddl.n197 vss 0.02438f
C97 vddl.n199 vss 0.10248f
C98 vddl.n201 vss 0.05598f
C99 vddl.n203 vss 0.05598f
C100 vddl.t8 vss 0.16709f
C101 vddl.t6 vss 0.13382f
C102 vddl.n205 vss 0.04193f
C103 vddl.n206 vss 0.01369f
C104 vddl.n207 vss 0.18863f
C105 vddl.n208 vss 0.27408f
C106 vddh.n0 vss 0.01822f
C107 vddh.n1 vss 1.43101f
C108 vddh.n2 vss 0.07737f
C109 vddh.t3 vss 0.03343f
C110 vddh.t23 vss 0.03343f
C111 vddh.n3 vss 1.03523f
C112 vddh.n4 vss 1.03523f
C113 vddh.n5 vss 0.37152f
C114 vddh.n6 vss 0.07737f
C115 vddh.t7 vss 0.03343f
C116 vddh.t5 vss 0.03343f
C117 vddh.n7 vss 0.16127f
C118 vddh.n8 vss 0.01735f
C119 vddh.n9 vss 0.43489f
C120 vddh.n10 vss 0.60346f
C121 vddh.n11 vss 0.07737f
C122 vddh.t13 vss 0.03343f
C123 vddh.t11 vss 0.03343f
C124 vddh.n12 vss 0.01865f
C125 vddh.n13 vss 0.43489f
C126 vddh.t14 vss 0.52152f
C127 vddh.t20 vss 0.4814f
C128 vddh.t12 vss 0.4814f
C129 vddh.t10 vss 0.58888f
C130 vddh.t8 vss 0.68197f
C131 vddh.t18 vss 0.4814f
C132 vddh.t6 vss 0.4814f
C133 vddh.t4 vss 0.58888f
C134 vddh.t0 vss 0.68197f
C135 vddh.t16 vss 0.4814f
C136 vddh.t2 vss 0.4814f
C137 vddh.t22 vss 0.70187f
C138 vddh.n14 vss 0.31605f
C139 a_500_120.t1 vss 0.12899f
C140 a_500_120.t0 vss 0.26487f
C141 a_500_120.t2 vss 0.52649f
C142 a_500_120.n0 vss 1.87001f
C143 a_2900_120.t0 vss 0.13327f
C144 a_2900_120.t1 vss 0.27365f
C145 a_2900_120.t2 vss 0.54394f
C146 a_2900_120.n0 vss 1.93197f
C147 a_5300_120.t1 vss 0.1326f
C148 a_5300_120.t0 vss 0.27228f
C149 a_5300_120.t2 vss 0.54123f
C150 a_5300_120.n0 vss 1.92235f
C151 a_260_3200.t1 vss 0.04773f
C152 a_260_3200.t4 vss 0.08088f
C153 a_260_3200.n0 vss 0.68241f
C154 a_260_3200.t3 vss 0.17099f
C155 a_260_3200.t2 vss 0.11314f
C156 a_260_3200.n1 vss 1.52511f
C157 a_260_3200.t0 vss 0.7678f
C158 a_260_3200.n2 vss 0.21729f
C159 a_840_3400.t1 vss 0.14515f
C160 a_840_3400.n0 vss 1.44699f
C161 a_840_3400.t2 vss 0.26321f
C162 a_840_3400.t0 vss 0.31757f
C163 a_840_3400.n1 vss 2.1157f
C164 a_840_3400.t3 vss 0.25679f
C165 a_2660_3200.t1 vss 0.049f
C166 a_2660_3200.t4 vss 0.08303f
C167 a_2660_3200.n0 vss 0.70055f
C168 a_2660_3200.t3 vss 0.17553f
C169 a_2660_3200.t2 vss 0.11615f
C170 a_2660_3200.n1 vss 1.56566f
C171 a_2660_3200.t0 vss 0.78822f
C172 a_2660_3200.n2 vss 0.22307f
C173 a_3240_3400.t1 vss 0.14575f
C174 a_3240_3400.n0 vss 1.45295f
C175 a_3240_3400.t2 vss 0.2643f
C176 a_3240_3400.t0 vss 0.31887f
C177 a_3240_3400.n1 vss 2.12441f
C178 a_3240_3400.t3 vss 0.25785f
C179 a_5060_3200.t1 vss 0.04899f
C180 a_5060_3200.t4 vss 0.08301f
C181 a_5060_3200.n0 vss 0.70045f
C182 a_5060_3200.t3 vss 0.17551f
C183 a_5060_3200.t2 vss 0.11614f
C184 a_5060_3200.n1 vss 1.56543f
C185 a_5060_3200.t0 vss 0.7881f
C186 a_5060_3200.n2 vss 0.22304f
C187 a_5640_3400.t1 vss 0.13535f
C188 a_5640_3400.n0 vss 1.34925f
C189 a_5640_3400.t2 vss 0.24543f
C190 a_5640_3400.t0 vss 0.29611f
C191 a_5640_3400.n1 vss 1.97278f
C192 a_5640_3400.t3 vss 0.23945f
C193 a_7440_3520.t1 vss 0.128f
C194 a_7440_3520.t0 vss 0.25728f
C195 a_7440_3520.t3 vss 0.20412f
C196 a_7440_3520.n0 vss 1.00206f
C197 a_7440_3520.t2 vss 0.13048f
C198 a_7440_3520.n1 vss 0.83469f
C199 a_120_180.t0 vss 0.02053f
C200 a_120_180.t2 vss 0.03409f
C201 a_120_180.n0 vss 0.67399f
C202 a_120_180.t1 vss 0.33729f
C203 x_sdata.t0 vss 0.30092f
C204 x_sdata.t1 vss 0.28296f
C205 x_sdata.n0 vss 1.92963f
C206 a_2520_180.t0 vss 0.03076f
C207 a_2520_180.t2 vss 0.05109f
C208 a_2520_180.n0 vss 1.01001f
C209 a_2520_180.t1 vss 0.50545f
C210 x_sclk.t0 vss 0.30093f
C211 x_sclk.t1 vss 0.28297f
C212 x_sclk.n0 vss 1.9297f
C213 a_4920_180.t0 vss 0.03076f
C214 a_4920_180.t2 vss 0.05109f
C215 a_4920_180.n0 vss 1.00999f
C216 a_4920_180.t1 vss 0.50543f
C217 x_rstn.t0 vss 0.27427f
C218 x_rstn.t1 vss 0.29167f
C219 x_rstn.n0 vss 1.87037f
C220 x_sout.t1 vss 0.10602f
C221 x_sout.t0 vss 0.23641f
.ends
