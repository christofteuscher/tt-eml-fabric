* NGSPICE file created from chainglue.ext - technology: sky130A

.subckt chainglue
X0 nu_next.t1 pbias vdd.t1 vdd.t0 sky130_fd_pr__pfet_g5v0d10v5 ad=6.6 pd=13.1 as=13.2 ps=26.2 w=12 l=8
X1 nout.t1 pbias vdd.t5 vdd.t4 sky130_fd_pr__pfet_g5v0d10v5 ad=6.6 pd=13.1 as=6.6 ps=13.1 w=12 l=8
X2 vg.t0 nout.t4 VSUB.t3 VSUB.t2 sky130_fd_pr__nfet_g5v0d10v5 ad=17.6 pd=34.2 as=8.8 ps=17.1 w=16 l=2
X3 vdd.t3 pbias nu_next.t0 vdd.t2 sky130_fd_pr__pfet_g5v0d10v5 ad=6.6 pd=13.1 as=6.6 ps=13.1 w=12 l=8
X4 vdd.t7 pbias nout.t0 vdd.t6 sky130_fd_pr__pfet_g5v0d10v5 ad=13.2 pd=26.2 as=6.6 ps=13.1 w=12 l=8
X5 VSUB.t1 nout.t2 nout.t3 VSUB.t0 sky130_fd_pr__nfet_g5v0d10v5 ad=8.8 pd=17.1 as=17.6 ps=34.2 w=16 l=2
X6 a_8800_4360.t0 vg.t2 vdd.t9 vdd.t8 sky130_fd_pr__pfet_g5v0d10v5 ad=4.4 pd=9.1 as=8.8 ps=18.2 w=8 l=2
X7 vg.t1 vcasc a_8800_4360.t1 vdd.t10 sky130_fd_pr__pfet_g5v0d10v5 ad=8.8 pd=18.2 as=4.4 ps=9.1 w=8 l=1
R0 a_8800_4360.t0 a_8800_4360.t1 26.263
R1 vg.n0 vg.t1 60.1661
R2 vg vg.n0 11.0161
R3 vg.n0 vg.t2 284.938
R4 vg vg.t0 17.3195
R5 nout.n0 nout.t1 8.75467
R6 nout.n0 nout.t0 8.75467
R7 nout.n2 nout.n0 39.3706
R8 nout nout.n1 0.484875
R9 nout.n1 nout.n2 0.96925
R10 nout.n2 nout.t4 375.231
R11 nout.n1 nout.t2 375.231
R12 nout nout.t3 17.5695
R13 nu_next.n0 nu_next.t1 8.75467
R14 nu_next.n0 nu_next.t0 8.75467
R15 nu_next nu_next.n0 32.5227
R16 vdd.t3 vdd.n0 8.75467
R17 vdd.n0 vdd.t5 8.75467
R18 vdd.n359 vdd.n0 27.3716
R19 vdd.n2 vdd.n1 9.3005
R20 vdd.n4 vdd.n3 9.3005
R21 vdd.n6 vdd.n5 9.3005
R22 vdd.n8 vdd.n7 9.3005
R23 vdd.n10 vdd.n9 9.3005
R24 vdd.n12 vdd.n11 9.3005
R25 vdd.n14 vdd.n13 9.3005
R26 vdd.n16 vdd.n15 9.3005
R27 vdd.n18 vdd.n17 9.3005
R28 vdd.n20 vdd.n19 9.3005
R29 vdd.n22 vdd.n21 9.3005
R30 vdd.n24 vdd.n23 9.3005
R31 vdd.n26 vdd.n25 9.3005
R32 vdd.n28 vdd.n27 9.3005
R33 vdd.n30 vdd.n29 9.3005
R34 vdd.n32 vdd.n31 9.3005
R35 vdd.n34 vdd.n33 9.3005
R36 vdd.n36 vdd.n35 9.3005
R37 vdd.n38 vdd.n37 9.3005
R38 vdd.n40 vdd.n39 9.3005
R39 vdd.n42 vdd.n41 9.3005
R40 vdd.n44 vdd.n43 9.3005
R41 vdd.n46 vdd.n45 9.3005
R42 vdd.n48 vdd.n47 9.3005
R43 vdd.n50 vdd.n49 9.3005
R44 vdd.n52 vdd.n51 9.3005
R45 vdd.n54 vdd.n53 9.3005
R46 vdd.n56 vdd.n55 9.3005
R47 vdd.n58 vdd.n57 9.3005
R48 vdd.n60 vdd.n59 9.3005
R49 vdd.n62 vdd.n61 9.3005
R50 vdd.n64 vdd.n63 9.3005
R51 vdd.n66 vdd.n65 9.3005
R52 vdd.n68 vdd.n67 9.3005
R53 vdd.n70 vdd.n69 9.3005
R54 vdd.n72 vdd.n71 9.3005
R55 vdd.n74 vdd.n73 9.3005
R56 vdd.n76 vdd.n75 9.3005
R57 vdd.n78 vdd.n77 9.3005
R58 vdd.n80 vdd.n79 9.3005
R59 vdd.n82 vdd.n81 9.3005
R60 vdd.n84 vdd.n83 9.3005
R61 vdd.n86 vdd.n85 9.3005
R62 vdd.n88 vdd.n87 9.3005
R63 vdd.n90 vdd.n89 9.3005
R64 vdd.n92 vdd.n91 9.3005
R65 vdd.n94 vdd.n93 9.3005
R66 vdd.n96 vdd.n95 9.3005
R67 vdd.n98 vdd.n97 9.3005
R68 vdd.n100 vdd.n99 9.3005
R69 vdd.n102 vdd.n101 9.3005
R70 vdd.n104 vdd.n103 9.3005
R71 vdd.n106 vdd.n105 9.3005
R72 vdd.n108 vdd.n107 9.3005
R73 vdd.n110 vdd.n109 9.3005
R74 vdd.n112 vdd.n111 9.3005
R75 vdd.n114 vdd.n113 9.3005
R76 vdd.n116 vdd.n115 9.3005
R77 vdd.n118 vdd.n117 9.3005
R78 vdd.n120 vdd.n119 9.3005
R79 vdd.n122 vdd.n121 9.3005
R80 vdd.n124 vdd.n123 9.3005
R81 vdd.n126 vdd.n125 9.3005
R82 vdd.n128 vdd.n127 9.3005
R83 vdd.n130 vdd.n129 9.3005
R84 vdd.n132 vdd.n131 9.3005
R85 vdd.n134 vdd.n133 9.3005
R86 vdd.n136 vdd.n135 9.3005
R87 vdd.n138 vdd.n137 9.3005
R88 vdd.n140 vdd.n139 9.3005
R89 vdd.n142 vdd.n141 9.3005
R90 vdd.n144 vdd.n143 9.3005
R91 vdd.n146 vdd.n145 9.3005
R92 vdd.n148 vdd.n147 9.3005
R93 vdd.n150 vdd.n149 9.3005
R94 vdd.n152 vdd.n151 9.3005
R95 vdd.n154 vdd.n153 9.3005
R96 vdd.n156 vdd.n155 9.3005
R97 vdd.n158 vdd.n157 9.3005
R98 vdd.n160 vdd.n159 9.3005
R99 vdd.n162 vdd.n161 9.3005
R100 vdd.n164 vdd.n163 9.3005
R101 vdd.n166 vdd.n165 9.3005
R102 vdd.n168 vdd.n167 9.3005
R103 vdd.n170 vdd.n169 9.3005
R104 vdd.n172 vdd.n171 9.3005
R105 vdd.n174 vdd.n173 9.3005
R106 vdd.n176 vdd.n175 9.3005
R107 vdd.n178 vdd.n177 9.3005
R108 vdd.n180 vdd.n179 4.28224
R109 vdd vdd.n2 0.016125
R110 vdd.n2 vdd.n4 0.15675
R111 vdd.n4 vdd.n6 0.15675
R112 vdd.n6 vdd.n8 0.15675
R113 vdd.n8 vdd.n10 0.15675
R114 vdd.n10 vdd.n12 0.15675
R115 vdd.n12 vdd.n14 0.15675
R116 vdd.n14 vdd.n16 0.15675
R117 vdd.n16 vdd.n18 0.15675
R118 vdd.n18 vdd.n20 0.15675
R119 vdd.n20 vdd.n22 0.15675
R120 vdd.n22 vdd.n24 0.15675
R121 vdd.n24 vdd.n26 0.15675
R122 vdd.n26 vdd.n28 0.15675
R123 vdd.n28 vdd.n30 0.15675
R124 vdd.n30 vdd.n32 0.15675
R125 vdd.n32 vdd.n34 0.15675
R126 vdd.n34 vdd.n36 0.15675
R127 vdd.n36 vdd.n38 0.15675
R128 vdd.n38 vdd.n40 0.15675
R129 vdd.n40 vdd.n42 0.15675
R130 vdd.n42 vdd.n44 0.15675
R131 vdd.n44 vdd.n46 0.15675
R132 vdd.n46 vdd.n48 0.15675
R133 vdd.n48 vdd.n50 0.15675
R134 vdd.n50 vdd.n52 0.15675
R135 vdd.n52 vdd.n54 0.15675
R136 vdd.n54 vdd.n56 0.15675
R137 vdd.n56 vdd.n58 0.15675
R138 vdd.n58 vdd.n60 0.15675
R139 vdd.n60 vdd.n62 0.15675
R140 vdd.n62 vdd.n64 0.15675
R141 vdd.n64 vdd.n66 0.15675
R142 vdd.n66 vdd.n68 0.15675
R143 vdd.n68 vdd.n70 0.15675
R144 vdd.n70 vdd.n72 0.15675
R145 vdd.n72 vdd.n74 0.15675
R146 vdd.n74 vdd.n359 0.047375
R147 vdd.n359 vdd.n76 0.109875
R148 vdd.n76 vdd.n78 0.15675
R149 vdd.n78 vdd.n80 0.15675
R150 vdd.n80 vdd.n82 0.15675
R151 vdd.n82 vdd.n84 0.15675
R152 vdd.n84 vdd.n86 0.15675
R153 vdd.n86 vdd.n88 0.15675
R154 vdd.n88 vdd.n90 0.15675
R155 vdd.n90 vdd.n92 0.15675
R156 vdd.n92 vdd.n94 0.15675
R157 vdd.n94 vdd.n96 0.15675
R158 vdd.n96 vdd.n98 0.15675
R159 vdd.n98 vdd.n100 0.15675
R160 vdd.n100 vdd.n102 0.15675
R161 vdd.n102 vdd.n104 0.15675
R162 vdd.n104 vdd.n106 0.15675
R163 vdd.n106 vdd.n108 0.15675
R164 vdd.n108 vdd.n110 0.15675
R165 vdd.n110 vdd.n112 0.15675
R166 vdd.n112 vdd.n114 0.15675
R167 vdd.n114 vdd.n116 0.15675
R168 vdd.n116 vdd.n118 0.15675
R169 vdd.n118 vdd.n120 0.15675
R170 vdd.n120 vdd.n122 0.15675
R171 vdd.n122 vdd.n124 0.15675
R172 vdd.n124 vdd.n126 0.15675
R173 vdd.n126 vdd.n128 0.15675
R174 vdd.n128 vdd.n130 0.15675
R175 vdd.n130 vdd.n132 0.15675
R176 vdd.n132 vdd.n134 0.15675
R177 vdd.n134 vdd.n136 0.15675
R178 vdd.n136 vdd.n138 0.15675
R179 vdd.n138 vdd.n140 0.15675
R180 vdd.n140 vdd.n142 0.15675
R181 vdd.n142 vdd.n144 0.15675
R182 vdd.n144 vdd.n146 0.15675
R183 vdd.n146 vdd.n357 0.109875
R184 vdd.n357 vdd.n148 0.047375
R185 vdd.n148 vdd.n150 0.15675
R186 vdd.n150 vdd.n152 0.15675
R187 vdd.n152 vdd.n154 0.15675
R188 vdd.n154 vdd.n156 0.15675
R189 vdd.n156 vdd.n158 0.15675
R190 vdd.n158 vdd.n160 0.15675
R191 vdd.n160 vdd.n358 0.109875
R192 vdd.n358 vdd.n162 0.047375
R193 vdd.n162 vdd.n164 0.15675
R194 vdd.n164 vdd.n166 0.15675
R195 vdd.n166 vdd.n168 0.15675
R196 vdd.n168 vdd.n170 0.15675
R197 vdd.n170 vdd.n172 0.15675
R198 vdd.n172 vdd.n174 0.15675
R199 vdd.n174 vdd.n176 0.15675
R200 vdd.n176 vdd.n178 0.15675
R201 vdd.n178 vdd.n180 2.68753
R202 vdd vdd.t1 36.1263
R203 vdd.n358 vdd.t9 55.1051
R204 vdd.n357 vdd.t7 36.1263
R205 vdd.n182 vdd.n181 40.8995
R206 vdd.n3 vdd.n182 185
R207 vdd.n183 vdd.n184 185
R208 vdd.n5 vdd.n184 185
R209 vdd.n185 vdd.n186 185
R210 vdd.n7 vdd.n186 185
R211 vdd.n188 vdd.n187 185
R212 vdd.n9 vdd.n188 185
R213 vdd.n190 vdd.n189 185
R214 vdd.n11 vdd.n190 185
R215 vdd.n192 vdd.n191 185
R216 vdd.n13 vdd.n192 185
R217 vdd.n194 vdd.n193 185
R218 vdd.n15 vdd.n194 185
R219 vdd.n196 vdd.n195 185
R220 vdd.n17 vdd.n196 185
R221 vdd.n197 vdd.t0 185
R222 vdd.n19 vdd.n197 185
R223 vdd.n199 vdd.n198 185
R224 vdd.n21 vdd.n199 185
R225 vdd.n201 vdd.n200 185
R226 vdd.n23 vdd.n201 185
R227 vdd.n203 vdd.n202 185
R228 vdd.n25 vdd.n203 185
R229 vdd.n205 vdd.n204 185
R230 vdd.n27 vdd.n205 185
R231 vdd.n207 vdd.n206 185
R232 vdd.n29 vdd.n207 185
R233 vdd.n209 vdd.n208 185
R234 vdd.n31 vdd.n209 185
R235 vdd.n211 vdd.n210 185
R236 vdd.n33 vdd.n211 185
R237 vdd.n213 vdd.n212 185
R238 vdd.n35 vdd.n213 185
R239 vdd.n215 vdd.n214 185
R240 vdd.n37 vdd.n215 185
R241 vdd.n217 vdd.n216 185
R242 vdd.n39 vdd.n217 185
R243 vdd.n219 vdd.n218 185
R244 vdd.n41 vdd.n219 185
R245 vdd.n221 vdd.n220 185
R246 vdd.n43 vdd.n221 185
R247 vdd.n223 vdd.n222 185
R248 vdd.n45 vdd.n223 185
R249 vdd.n225 vdd.n224 185
R250 vdd.n47 vdd.n225 185
R251 vdd.n227 vdd.n226 185
R252 vdd.n49 vdd.n227 185
R253 vdd.n229 vdd.n228 185
R254 vdd.n51 vdd.n229 185
R255 vdd.n231 vdd.n230 185
R256 vdd.n53 vdd.n231 185
R257 vdd.n233 vdd.n232 185
R258 vdd.n55 vdd.n233 185
R259 vdd.n235 vdd.n234 185
R260 vdd.n57 vdd.n235 185
R261 vdd.n237 vdd.n236 185
R262 vdd.n59 vdd.n237 185
R263 vdd.n239 vdd.n238 185
R264 vdd.n61 vdd.n239 185
R265 vdd.n241 vdd.n240 185
R266 vdd.n63 vdd.n241 185
R267 vdd.n243 vdd.n242 185
R268 vdd.n65 vdd.n243 185
R269 vdd.n245 vdd.n244 185
R270 vdd.n67 vdd.n245 185
R271 vdd.n247 vdd.n246 185
R272 vdd.n69 vdd.n247 185
R273 vdd.n249 vdd.n248 185
R274 vdd.n71 vdd.n249 185
R275 vdd.n251 vdd.n250 185
R276 vdd.n73 vdd.n251 185
R277 vdd.n253 vdd.n252 185
R278 vdd.n75 vdd.n253 185
R279 vdd.n255 vdd.n254 185
R280 vdd.n77 vdd.n255 185
R281 vdd.n257 vdd.n256 185
R282 vdd.n79 vdd.n257 185
R283 vdd.n259 vdd.n258 185
R284 vdd.n81 vdd.n259 185
R285 vdd.n261 vdd.n260 185
R286 vdd.n83 vdd.n261 185
R287 vdd.n263 vdd.n262 185
R288 vdd.n85 vdd.n263 185
R289 vdd.n265 vdd.n264 185
R290 vdd.n87 vdd.n265 185
R291 vdd.n267 vdd.n266 185
R292 vdd.n89 vdd.n267 185
R293 vdd.n269 vdd.n268 185
R294 vdd.n91 vdd.n269 185
R295 vdd.n271 vdd.n270 185
R296 vdd.n93 vdd.n271 185
R297 vdd.n273 vdd.n272 185
R298 vdd.n95 vdd.n273 185
R299 vdd.n275 vdd.n274 185
R300 vdd.n97 vdd.n275 185
R301 vdd.n277 vdd.n276 185
R302 vdd.n99 vdd.n277 185
R303 vdd.n279 vdd.n278 185
R304 vdd.n101 vdd.n279 185
R305 vdd.n281 vdd.n280 185
R306 vdd.n103 vdd.n281 185
R307 vdd.n283 vdd.n282 185
R308 vdd.n105 vdd.n283 185
R309 vdd.n285 vdd.n284 185
R310 vdd.n107 vdd.n285 185
R311 vdd.n287 vdd.n286 185
R312 vdd.n109 vdd.n287 185
R313 vdd.n289 vdd.n288 185
R314 vdd.n111 vdd.n289 185
R315 vdd.n291 vdd.n290 185
R316 vdd.n113 vdd.n291 185
R317 vdd.n293 vdd.n292 185
R318 vdd.n115 vdd.n293 185
R319 vdd.n295 vdd.n294 185
R320 vdd.n117 vdd.n295 185
R321 vdd.n297 vdd.n296 185
R322 vdd.n119 vdd.n297 185
R323 vdd.n299 vdd.n298 185
R324 vdd.n121 vdd.n299 185
R325 vdd.n301 vdd.n300 185
R326 vdd.n123 vdd.n301 185
R327 vdd.n303 vdd.n302 185
R328 vdd.n125 vdd.n303 185
R329 vdd.n305 vdd.n304 185
R330 vdd.n127 vdd.n305 185
R331 vdd.n307 vdd.n306 185
R332 vdd.n129 vdd.n307 185
R333 vdd.n309 vdd.n308 185
R334 vdd.n131 vdd.n309 185
R335 vdd.n311 vdd.n310 185
R336 vdd.n133 vdd.n311 185
R337 vdd.n313 vdd.n312 185
R338 vdd.n135 vdd.n313 185
R339 vdd.n315 vdd.n314 185
R340 vdd.n137 vdd.n315 185
R341 vdd.n317 vdd.n316 185
R342 vdd.n139 vdd.n317 185
R343 vdd.n319 vdd.n318 185
R344 vdd.n141 vdd.n319 185
R345 vdd.n321 vdd.n320 185
R346 vdd.n143 vdd.n321 185
R347 vdd.n323 vdd.n322 185
R348 vdd.n145 vdd.n323 185
R349 vdd.n325 vdd.n324 185
R350 vdd.n147 vdd.n325 185
R351 vdd.n327 vdd.n326 185
R352 vdd.n149 vdd.n327 185
R353 vdd.n329 vdd.n328 185
R354 vdd.n151 vdd.n329 185
R355 vdd.n331 vdd.n330 185
R356 vdd.n153 vdd.n331 185
R357 vdd.n333 vdd.n332 185
R358 vdd.n155 vdd.n333 185
R359 vdd.n335 vdd.n334 185
R360 vdd.n157 vdd.n335 185
R361 vdd.n337 vdd.n336 185
R362 vdd.n159 vdd.n337 185
R363 vdd.n339 vdd.n338 185
R364 vdd.n161 vdd.n339 185
R365 vdd.n341 vdd.n340 185
R366 vdd.n163 vdd.n341 185
R367 vdd.n343 vdd.n342 185
R368 vdd.n165 vdd.n343 185
R369 vdd.n345 vdd.n344 185
R370 vdd.n167 vdd.n345 185
R371 vdd.n347 vdd.n346 185
R372 vdd.n169 vdd.n347 185
R373 vdd.n349 vdd.n348 185
R374 vdd.n171 vdd.n349 185
R375 vdd.n351 vdd.n350 185
R376 vdd.n173 vdd.n351 185
R377 vdd.n352 vdd.n353 185
R378 vdd.n175 vdd.n353 185
R379 vdd.t10 vdd.n354 185
R380 vdd.n177 vdd.n354 185
R381 vdd.n179 vdd.n356 185
R382 vdd.n355 vdd.n180 237.254
R383 vdd.n1 vdd.n3 16.0005
R384 vdd.n3 vdd.n5 16.0005
R385 vdd.n5 vdd.n7 16.0005
R386 vdd.n7 vdd.n9 16.0005
R387 vdd.n9 vdd.n11 16.0005
R388 vdd.n11 vdd.n13 16.0005
R389 vdd.n13 vdd.n15 16.0005
R390 vdd.n15 vdd.n17 16.0005
R391 vdd.n17 vdd.n19 16.0005
R392 vdd.n19 vdd.n21 16.0005
R393 vdd.n21 vdd.n23 16.0005
R394 vdd.n23 vdd.n25 16.0005
R395 vdd.n25 vdd.n27 16.0005
R396 vdd.n27 vdd.n29 16.0005
R397 vdd.n29 vdd.n31 16.0005
R398 vdd.n31 vdd.n33 16.0005
R399 vdd.n33 vdd.n35 16.0005
R400 vdd.n35 vdd.n37 16.0005
R401 vdd.n37 vdd.n39 16.0005
R402 vdd.n39 vdd.n41 16.0005
R403 vdd.n41 vdd.n43 16.0005
R404 vdd.n43 vdd.n45 16.0005
R405 vdd.n45 vdd.n47 16.0005
R406 vdd.n47 vdd.n49 16.0005
R407 vdd.n49 vdd.n51 16.0005
R408 vdd.n51 vdd.n53 16.0005
R409 vdd.n53 vdd.n55 16.0005
R410 vdd.n55 vdd.n57 16.0005
R411 vdd.n57 vdd.n59 16.0005
R412 vdd.n59 vdd.n61 16.0005
R413 vdd.n61 vdd.n63 16.0005
R414 vdd.n63 vdd.n65 16.0005
R415 vdd.n65 vdd.n67 16.0005
R416 vdd.n67 vdd.n69 16.0005
R417 vdd.n69 vdd.n71 16.0005
R418 vdd.n71 vdd.n73 16.0005
R419 vdd.n73 vdd.n75 16.0005
R420 vdd.n75 vdd.n77 16.0005
R421 vdd.n77 vdd.n79 16.0005
R422 vdd.n79 vdd.n81 16.0005
R423 vdd.n81 vdd.n83 16.0005
R424 vdd.n83 vdd.n85 16.0005
R425 vdd.n85 vdd.n87 16.0005
R426 vdd.n87 vdd.n89 16.0005
R427 vdd.n89 vdd.n91 16.0005
R428 vdd.n91 vdd.n93 16.0005
R429 vdd.n93 vdd.n95 16.0005
R430 vdd.n95 vdd.n97 16.0005
R431 vdd.n97 vdd.n99 16.0005
R432 vdd.n99 vdd.n101 16.0005
R433 vdd.n101 vdd.n103 16.0005
R434 vdd.n103 vdd.n105 16.0005
R435 vdd.n105 vdd.n107 16.0005
R436 vdd.n107 vdd.n109 16.0005
R437 vdd.n109 vdd.n111 16.0005
R438 vdd.n111 vdd.n113 16.0005
R439 vdd.n113 vdd.n115 16.0005
R440 vdd.n115 vdd.n117 16.0005
R441 vdd.n117 vdd.n119 16.0005
R442 vdd.n119 vdd.n121 16.0005
R443 vdd.n121 vdd.n123 16.0005
R444 vdd.n123 vdd.n125 16.0005
R445 vdd.n125 vdd.n127 16.0005
R446 vdd.n127 vdd.n129 16.0005
R447 vdd.n129 vdd.n131 16.0005
R448 vdd.n131 vdd.n133 16.0005
R449 vdd.n133 vdd.n135 16.0005
R450 vdd.n135 vdd.n137 16.0005
R451 vdd.n137 vdd.n139 16.0005
R452 vdd.n139 vdd.n141 16.0005
R453 vdd.n141 vdd.n143 16.0005
R454 vdd.n143 vdd.n145 16.0005
R455 vdd.n145 vdd.n147 16.0005
R456 vdd.n147 vdd.n149 16.0005
R457 vdd.n149 vdd.n151 16.0005
R458 vdd.n151 vdd.n153 16.0005
R459 vdd.n153 vdd.n155 16.0005
R460 vdd.n155 vdd.n157 16.0005
R461 vdd.n157 vdd.n159 16.0005
R462 vdd.n159 vdd.n161 16.0005
R463 vdd.n161 vdd.n163 16.0005
R464 vdd.n163 vdd.n165 16.0005
R465 vdd.n165 vdd.n167 16.0005
R466 vdd.n167 vdd.n169 16.0005
R467 vdd.n169 vdd.n171 16.0005
R468 vdd.n171 vdd.n173 16.0005
R469 vdd.n173 vdd.n175 16.0005
R470 vdd.n175 vdd.n177 16.0005
R471 vdd.n177 vdd.n179 16.0005
R472 vdd.n1 vdd.n181 232.9
R473 vdd.n182 vdd.n184 114.001
R474 vdd.n184 vdd.n186 114.001
R475 vdd.n186 vdd.n188 114.001
R476 vdd.n188 vdd.n190 114.001
R477 vdd.n190 vdd.n192 114.001
R478 vdd.n192 vdd.n194 114.001
R479 vdd.n194 vdd.n196 114.001
R480 vdd.n196 vdd.n197 114.001
R481 vdd.n197 vdd.n199 114.001
R482 vdd.n199 vdd.n201 114.001
R483 vdd.n201 vdd.n203 114.001
R484 vdd.n203 vdd.n205 114.001
R485 vdd.n205 vdd.n207 114.001
R486 vdd.n207 vdd.n209 114.001
R487 vdd.n209 vdd.n211 114.001
R488 vdd.n211 vdd.n213 114.001
R489 vdd.n213 vdd.n215 114.001
R490 vdd.n215 vdd.n217 114.001
R491 vdd.n217 vdd.n219 114.001
R492 vdd.n219 vdd.n221 114.001
R493 vdd.n221 vdd.n223 114.001
R494 vdd.n223 vdd.n225 114.001
R495 vdd.n225 vdd.n227 114.001
R496 vdd.n227 vdd.n229 114.001
R497 vdd.n229 vdd.n231 114.001
R498 vdd.n231 vdd.n233 114.001
R499 vdd.n233 vdd.n235 114.001
R500 vdd.n235 vdd.n237 114.001
R501 vdd.n237 vdd.n239 114.001
R502 vdd.n239 vdd.n241 114.001
R503 vdd.n241 vdd.n243 114.001
R504 vdd.n243 vdd.n245 114.001
R505 vdd.n245 vdd.n247 114.001
R506 vdd.n247 vdd.n249 114.001
R507 vdd.n249 vdd.n251 114.001
R508 vdd.n251 vdd.n253 114.001
R509 vdd.n253 vdd.n255 114.001
R510 vdd.n255 vdd.n257 114.001
R511 vdd.n257 vdd.n259 114.001
R512 vdd.n259 vdd.n261 114.001
R513 vdd.n261 vdd.n263 114.001
R514 vdd.n263 vdd.n265 114.001
R515 vdd.n265 vdd.n267 114.001
R516 vdd.n267 vdd.n269 114.001
R517 vdd.n269 vdd.n271 114.001
R518 vdd.n271 vdd.n273 114.001
R519 vdd.n273 vdd.n275 114.001
R520 vdd.n275 vdd.n277 114.001
R521 vdd.n277 vdd.n279 114.001
R522 vdd.n279 vdd.n281 114.001
R523 vdd.n281 vdd.n283 114.001
R524 vdd.n283 vdd.n285 114.001
R525 vdd.n285 vdd.n287 114.001
R526 vdd.n287 vdd.n289 114.001
R527 vdd.n289 vdd.n291 114.001
R528 vdd.n291 vdd.n293 114.001
R529 vdd.n293 vdd.n295 114.001
R530 vdd.n295 vdd.n297 114.001
R531 vdd.n297 vdd.n299 114.001
R532 vdd.n299 vdd.n301 114.001
R533 vdd.n301 vdd.n303 114.001
R534 vdd.n303 vdd.n305 114.001
R535 vdd.n305 vdd.n307 114.001
R536 vdd.n307 vdd.n309 114.001
R537 vdd.n309 vdd.n311 114.001
R538 vdd.n311 vdd.n313 114.001
R539 vdd.n313 vdd.n315 114.001
R540 vdd.n315 vdd.n317 114.001
R541 vdd.n317 vdd.n319 114.001
R542 vdd.n319 vdd.n321 114.001
R543 vdd.n321 vdd.n323 114.001
R544 vdd.n323 vdd.n325 114.001
R545 vdd.n325 vdd.n327 114.001
R546 vdd.n327 vdd.n329 114.001
R547 vdd.n329 vdd.n331 114.001
R548 vdd.n331 vdd.n333 114.001
R549 vdd.n333 vdd.n335 114.001
R550 vdd.n335 vdd.n337 114.001
R551 vdd.n337 vdd.n339 114.001
R552 vdd.n339 vdd.n341 114.001
R553 vdd.n341 vdd.n343 114.001
R554 vdd.n343 vdd.n345 114.001
R555 vdd.n345 vdd.n347 114.001
R556 vdd.n347 vdd.n349 114.001
R557 vdd.n349 vdd.n351 114.001
R558 vdd.n351 vdd.n353 114.001
R559 vdd.n353 vdd.n354 114.001
R560 vdd.n354 vdd.n356 114.001
R561 vdd.n356 vdd.n355 40.8995
R562 vdd.n181 vdd.n183 109.398
R563 vdd.n183 vdd.n185 31.6672
R564 vdd.n185 vdd.n187 31.6672
R565 vdd.n187 vdd.n189 31.6672
R566 vdd.n189 vdd.n191 31.6672
R567 vdd.n191 vdd.n193 31.6672
R568 vdd.n193 vdd.n195 31.6672
R569 vdd.n195 vdd.t0 31.6672
R570 vdd.t0 vdd.n198 31.6672
R571 vdd.n198 vdd.n200 31.6672
R572 vdd.n200 vdd.n202 31.6672
R573 vdd.n202 vdd.n204 31.6672
R574 vdd.n204 vdd.n206 31.6672
R575 vdd.n206 vdd.n208 31.6672
R576 vdd.n208 vdd.n210 31.6672
R577 vdd.n210 vdd.n212 31.6672
R578 vdd.n212 vdd.n214 31.6672
R579 vdd.n214 vdd.n216 31.6672
R580 vdd.n216 vdd.n218 31.6672
R581 vdd.n218 vdd.n220 31.6672
R582 vdd.n220 vdd.n222 31.6672
R583 vdd.n222 vdd.n224 31.6672
R584 vdd.n224 vdd.n226 31.6672
R585 vdd.n226 vdd.n228 31.6672
R586 vdd.n228 vdd.n230 31.6672
R587 vdd.n230 vdd.n232 31.6672
R588 vdd.n232 vdd.t2 6.33383
R589 vdd.t2 vdd.n234 25.3338
R590 vdd.n234 vdd.n236 31.6672
R591 vdd.n236 vdd.n238 31.6672
R592 vdd.n238 vdd.n240 31.6672
R593 vdd.n240 vdd.n242 31.6672
R594 vdd.n242 vdd.n244 31.6672
R595 vdd.n244 vdd.n246 31.6672
R596 vdd.n246 vdd.n248 31.6672
R597 vdd.n248 vdd.n250 31.6672
R598 vdd.n250 vdd.n252 31.6672
R599 vdd.n252 vdd.n254 31.6672
R600 vdd.n254 vdd.n256 31.6672
R601 vdd.n256 vdd.n258 31.6672
R602 vdd.n258 vdd.n260 31.6672
R603 vdd.n260 vdd.n262 31.6672
R604 vdd.n262 vdd.n264 31.6672
R605 vdd.n264 vdd.n266 31.6672
R606 vdd.n266 vdd.n268 31.6672
R607 vdd.n268 vdd.t4 12.6672
R608 vdd.t4 vdd.n270 19.0005
R609 vdd.n270 vdd.n272 31.6672
R610 vdd.n272 vdd.n274 31.6672
R611 vdd.n274 vdd.n276 31.6672
R612 vdd.n276 vdd.n278 31.6672
R613 vdd.n278 vdd.n280 31.6672
R614 vdd.n280 vdd.n282 31.6672
R615 vdd.n282 vdd.n284 31.6672
R616 vdd.n284 vdd.n286 31.6672
R617 vdd.n286 vdd.n288 31.6672
R618 vdd.n288 vdd.n290 31.6672
R619 vdd.n290 vdd.n292 31.6672
R620 vdd.n292 vdd.n294 31.6672
R621 vdd.n294 vdd.n296 31.6672
R622 vdd.n296 vdd.n298 31.6672
R623 vdd.n298 vdd.n300 31.6672
R624 vdd.n300 vdd.n302 31.6672
R625 vdd.n302 vdd.n304 31.6672
R626 vdd.n304 vdd.t6 19.0005
R627 vdd.n306 vdd.t6 12.6672
R628 vdd.n306 vdd.n308 31.6672
R629 vdd.n308 vdd.n310 31.6672
R630 vdd.n310 vdd.n312 31.6672
R631 vdd.n312 vdd.n314 31.6672
R632 vdd.n314 vdd.n316 31.6672
R633 vdd.n316 vdd.n318 31.6672
R634 vdd.n318 vdd.n320 31.6672
R635 vdd.n320 vdd.n322 31.6672
R636 vdd.n322 vdd.n324 31.6672
R637 vdd.n324 vdd.n326 31.6672
R638 vdd.n326 vdd.n328 31.6672
R639 vdd.n328 vdd.n330 31.6672
R640 vdd.n330 vdd.n332 31.6672
R641 vdd.n332 vdd.n334 31.6672
R642 vdd.n334 vdd.n336 31.6672
R643 vdd.n336 vdd.n338 31.6672
R644 vdd.n338 vdd.n340 31.6672
R645 vdd.n340 vdd.n342 31.6672
R646 vdd.n342 vdd.t8 25.3338
R647 vdd.n344 vdd.t8 6.33383
R648 vdd.n344 vdd.n346 31.6672
R649 vdd.n346 vdd.n348 31.6672
R650 vdd.n348 vdd.n350 31.6672
R651 vdd.n350 vdd.n352 31.6672
R652 vdd.t10 vdd.n352 31.6672
R653 vdd.n355 vdd.t10 109.398
R654 VSUB.t1 VSUB.n0 3.91925
R655 VSUB.n0 VSUB.t3 3.91925
R656 VSUB VSUB.n0 8.63362
R657 VSUB.n2 VSUB.n3 4.28224
R658 VSUB.n5 VSUB.n4 9.3005
R659 VSUB.n7 VSUB.n6 9.3005
R660 VSUB.n9 VSUB.n8 9.3005
R661 VSUB.n11 VSUB.n10 9.3005
R662 VSUB VSUB.n12 9.3005
R663 VSUB.n14 VSUB.n13 9.3005
R664 VSUB.n16 VSUB.n15 9.3005
R665 VSUB.n18 VSUB.n17 9.3005
R666 VSUB.n20 VSUB.n19 9.3005
R667 VSUB.n1 VSUB.n21 4.28224
R668 VSUB.n5 VSUB.n2 2.68753
R669 VSUB.n7 VSUB.n5 0.15675
R670 VSUB.n9 VSUB.n7 0.15675
R671 VSUB.n11 VSUB.n9 0.15675
R672 VSUB VSUB.n11 0.15675
R673 VSUB VSUB.n14 0.15675
R674 VSUB.n14 VSUB.n16 0.15675
R675 VSUB.n16 VSUB.n18 0.15675
R676 VSUB.n18 VSUB.n20 0.15675
R677 VSUB.n20 VSUB.n1 2.68753
R678 VSUB.n23 VSUB.n22 585
R679 VSUB.n1 VSUB.n23 589.355
R680 VSUB.n25 VSUB.n24 585
R681 VSUB.n21 VSUB.n25 585
R682 VSUB.n27 VSUB.n26 585
R683 VSUB.n19 VSUB.n27 585
R684 VSUB.n29 VSUB.n28 585
R685 VSUB.n17 VSUB.n29 585
R686 VSUB.n31 VSUB.n30 585
R687 VSUB.n15 VSUB.n31 585
R688 VSUB.n33 VSUB.n32 585
R689 VSUB.n13 VSUB.n33 585
R690 VSUB.n35 VSUB.n34 585
R691 VSUB.n12 VSUB.n35 585
R692 VSUB.n37 VSUB.n36 585
R693 VSUB.n10 VSUB.n37 585
R694 VSUB.n39 VSUB.n38 585
R695 VSUB.n8 VSUB.n39 585
R696 VSUB.n40 VSUB.n41 585
R697 VSUB.n6 VSUB.n41 585
R698 VSUB.n42 VSUB.n43 585
R699 VSUB.n4 VSUB.n43 585
R700 VSUB.n3 VSUB.n45 585
R701 VSUB.n44 VSUB.n2 680.962
R702 VSUB.n3 VSUB.n4 16.0005
R703 VSUB.n4 VSUB.n6 16.0005
R704 VSUB.n6 VSUB.n8 16.0005
R705 VSUB.n8 VSUB.n10 16.0005
R706 VSUB.n10 VSUB.n12 16.0005
R707 VSUB.n12 VSUB.n13 16.0005
R708 VSUB.n13 VSUB.n15 16.0005
R709 VSUB.n15 VSUB.n17 16.0005
R710 VSUB.n17 VSUB.n19 16.0005
R711 VSUB.n19 VSUB.n21 16.0005
R712 VSUB.n45 VSUB.n44 78.8438
R713 VSUB.n45 VSUB.n43 197
R714 VSUB.n43 VSUB.n41 197
R715 VSUB.n41 VSUB.n39 197
R716 VSUB.n39 VSUB.n37 197
R717 VSUB.n37 VSUB.n35 197
R718 VSUB.n35 VSUB.n33 197
R719 VSUB.n33 VSUB.n31 197
R720 VSUB.n31 VSUB.n29 197
R721 VSUB.n29 VSUB.n27 197
R722 VSUB.n27 VSUB.n25 197
R723 VSUB.n25 VSUB.n23 197
R724 VSUB.n46 VSUB.n47 585
R725 VSUB.n50 VSUB.n48 55.1435
R726 VSUB.n48 VSUB.n49 585
R727 VSUB.n46 VSUB.n50 264.93
R728 VSUB.n51 VSUB.n52 585
R729 VSUB.n55 VSUB.n53 55.1435
R730 VSUB.n53 VSUB.n54 585
R731 VSUB.n46 VSUB.n55 264.93
R732 VSUB.n56 VSUB.n57 585
R733 VSUB.n60 VSUB.n58 55.1435
R734 VSUB.n58 VSUB.n59 585
R735 VSUB.n46 VSUB.n60 264.93
R736 VSUB.n61 VSUB.n62 585
R737 VSUB.n65 VSUB.n63 55.1435
R738 VSUB.n63 VSUB.n64 585
R739 VSUB.n46 VSUB.n65 264.93
R740 VSUB.n66 VSUB.n67 585
R741 VSUB.n70 VSUB.n68 55.1435
R742 VSUB.n68 VSUB.n69 585
R743 VSUB.n46 VSUB.n70 264.93
R744 VSUB.n71 VSUB.n72 585
R745 VSUB.n75 VSUB.n73 55.1435
R746 VSUB.n73 VSUB.n74 585
R747 VSUB.n46 VSUB.n75 264.93
R748 VSUB.n76 VSUB.n77 585
R749 VSUB.n80 VSUB.n78 55.1435
R750 VSUB.n78 VSUB.n79 585
R751 VSUB.n46 VSUB.n80 264.93
R752 VSUB.n81 VSUB.n82 585
R753 VSUB.n85 VSUB.n83 55.1435
R754 VSUB.n83 VSUB.n84 585
R755 VSUB.n46 VSUB.n85 264.93
R756 VSUB.n86 VSUB.n87 585
R757 VSUB.n90 VSUB.n88 55.1435
R758 VSUB.n88 VSUB.n89 585
R759 VSUB.n46 VSUB.n90 264.93
R760 VSUB.n91 VSUB.n92 585
R761 VSUB.n95 VSUB.n93 55.1435
R762 VSUB.n93 VSUB.n94 585
R763 VSUB.n46 VSUB.n95 264.93
R764 VSUB.n96 VSUB.n97 585
R765 VSUB.n100 VSUB.n98 55.1435
R766 VSUB.n98 VSUB.n99 585
R767 VSUB.n46 VSUB.n100 264.93
R768 VSUB.n101 VSUB.n102 585
R769 VSUB.n105 VSUB.n103 55.1435
R770 VSUB.n103 VSUB.n104 585
R771 VSUB.n46 VSUB.n105 264.93
R772 VSUB.n106 VSUB.n107 585
R773 VSUB.n110 VSUB.n108 55.1435
R774 VSUB.n108 VSUB.n109 585
R775 VSUB.n46 VSUB.n110 264.93
R776 VSUB.n111 VSUB.n112 585
R777 VSUB.n115 VSUB.n113 55.1435
R778 VSUB.n113 VSUB.n114 585
R779 VSUB.n46 VSUB.n115 264.93
R780 VSUB.n116 VSUB.n117 585
R781 VSUB.n120 VSUB.n118 55.1435
R782 VSUB.n118 VSUB.n119 585
R783 VSUB.n46 VSUB.n120 264.93
R784 VSUB.n121 VSUB.n122 585
R785 VSUB.n46 VSUB.n123 264.93
R786 VSUB.n124 VSUB.n125 585
R787 VSUB.n44 VSUB.n42 366.736
R788 VSUB.n42 VSUB.t0 85.2351
R789 VSUB.t0 VSUB.n40 9.47101
R790 VSUB.n40 VSUB.n38 94.7056
R791 VSUB.n38 VSUB.n36 94.7056
R792 VSUB.n36 VSUB.n34 94.7056
R793 VSUB.n34 VSUB.n32 94.7056
R794 VSUB.n32 VSUB.n30 94.7056
R795 VSUB.n30 VSUB.n28 94.7056
R796 VSUB.n28 VSUB.t2 9.47101
R797 VSUB.t2 VSUB.n26 85.2351
R798 VSUB.n26 VSUB.n24 94.7056
R799 VSUB.n24 VSUB.n22 94.7056
R800 VSUB.n22 VSUB.n46 293.587
R801 VSUB.n49 VSUB.n127 3.15647
R802 VSUB.n52 VSUB.n128 9.3005
R803 VSUB.n54 VSUB.n129 9.3005
R804 VSUB.n57 VSUB.n130 9.3005
R805 VSUB.n59 VSUB.n131 9.3005
R806 VSUB.n62 VSUB.n132 9.3005
R807 VSUB.n64 VSUB.n133 9.3005
R808 VSUB.n67 VSUB.n134 9.3005
R809 VSUB.n69 VSUB.n135 9.3005
R810 VSUB.n72 VSUB.n136 9.3005
R811 VSUB.n74 VSUB.n137 9.3005
R812 VSUB.n77 VSUB.n138 9.3005
R813 VSUB.n79 VSUB.n139 9.3005
R814 VSUB.n82 VSUB.n140 9.3005
R815 VSUB.n84 VSUB.n141 9.3005
R816 VSUB.n87 VSUB.n142 9.3005
R817 VSUB.n89 VSUB.n143 9.3005
R818 VSUB.n92 VSUB.n144 9.3005
R819 VSUB.n94 VSUB.n145 9.3005
R820 VSUB.n97 VSUB.n146 9.3005
R821 VSUB.n99 VSUB.n147 9.3005
R822 VSUB.n102 VSUB.n148 9.3005
R823 VSUB.n104 VSUB.n149 9.3005
R824 VSUB.n107 VSUB.n150 9.3005
R825 VSUB.n109 VSUB.n151 9.3005
R826 VSUB.n112 VSUB.n152 9.3005
R827 VSUB.n114 VSUB.n153 9.3005
R828 VSUB.n117 VSUB.n154 9.3005
R829 VSUB.n119 VSUB.n155 9.3005
R830 VSUB.n122 VSUB.n156 9.3005
R831 VSUB.n125 VSUB.n126 3.15647
R832 VSUB.n47 VSUB.n127 588.188
R833 VSUB.n49 VSUB.n52 9.6005
R834 VSUB.n52 VSUB.n54 9.6005
R835 VSUB.n54 VSUB.n57 9.6005
R836 VSUB.n57 VSUB.n59 9.6005
R837 VSUB.n59 VSUB.n62 9.6005
R838 VSUB.n62 VSUB.n64 9.6005
R839 VSUB.n64 VSUB.n67 9.6005
R840 VSUB.n67 VSUB.n69 9.6005
R841 VSUB.n69 VSUB.n72 9.6005
R842 VSUB.n72 VSUB.n74 9.6005
R843 VSUB.n74 VSUB.n77 9.6005
R844 VSUB.n77 VSUB.n79 9.6005
R845 VSUB.n79 VSUB.n82 9.6005
R846 VSUB.n82 VSUB.n84 9.6005
R847 VSUB.n84 VSUB.n87 9.6005
R848 VSUB.n87 VSUB.n89 9.6005
R849 VSUB.n89 VSUB.n92 9.6005
R850 VSUB.n92 VSUB.n94 9.6005
R851 VSUB.n94 VSUB.n97 9.6005
R852 VSUB.n97 VSUB.n99 9.6005
R853 VSUB.n99 VSUB.n102 9.6005
R854 VSUB.n102 VSUB.n104 9.6005
R855 VSUB.n104 VSUB.n107 9.6005
R856 VSUB.n107 VSUB.n109 9.6005
R857 VSUB.n109 VSUB.n112 9.6005
R858 VSUB.n112 VSUB.n114 9.6005
R859 VSUB.n114 VSUB.n117 9.6005
R860 VSUB.n117 VSUB.n119 9.6005
R861 VSUB.n119 VSUB.n122 9.6005
R862 VSUB.n122 VSUB.n125 9.6005
R863 VSUB.n126 VSUB.n123 643.332
R864 VSUB.n127 VSUB.n128 3.18242
R865 VSUB.n128 VSUB.n129 0.09425
R866 VSUB.n129 VSUB.n130 0.09425
R867 VSUB.n130 VSUB.n131 0.09425
R868 VSUB.n131 VSUB.n132 0.09425
R869 VSUB.n132 VSUB.n133 0.09425
R870 VSUB.n133 VSUB.n134 0.09425
R871 VSUB.n134 VSUB.n135 0.09425
R872 VSUB.n135 VSUB.n136 0.09425
R873 VSUB.n136 VSUB.n137 0.09425
R874 VSUB.n137 VSUB.n138 0.09425
R875 VSUB.n138 VSUB.n139 0.09425
R876 VSUB.n139 VSUB.n140 0.09425
R877 VSUB.n140 VSUB.n141 0.09425
R878 VSUB.n141 VSUB.n142 0.09425
R879 VSUB.n143 VSUB.n142 0.09425
R880 VSUB.n144 VSUB.n143 0.09425
R881 VSUB.n145 VSUB.n144 0.09425
R882 VSUB.n146 VSUB.n145 0.09425
R883 VSUB.n147 VSUB.n146 0.09425
R884 VSUB.n148 VSUB.n147 0.09425
R885 VSUB.n149 VSUB.n148 0.09425
R886 VSUB.n150 VSUB.n149 0.09425
R887 VSUB.n151 VSUB.n150 0.09425
R888 VSUB.n152 VSUB.n151 0.09425
R889 VSUB.n153 VSUB.n152 0.09425
R890 VSUB.n154 VSUB.n153 0.09425
R891 VSUB.n155 VSUB.n154 0.09425
R892 VSUB.n156 VSUB.n155 0.09425
R893 VSUB.n126 VSUB.n156 3.18242
R894 VSUB.n48 VSUB.n47 121.763
R895 VSUB.n50 VSUB.n51 55.1435
R896 VSUB.n51 VSUB.n53 121.763
R897 VSUB.n55 VSUB.n56 55.1435
R898 VSUB.n56 VSUB.n58 121.763
R899 VSUB.n60 VSUB.n61 55.1435
R900 VSUB.n61 VSUB.n63 121.763
R901 VSUB.n65 VSUB.n66 55.1435
R902 VSUB.n66 VSUB.n68 121.763
R903 VSUB.n70 VSUB.n71 55.1435
R904 VSUB.n71 VSUB.n73 121.763
R905 VSUB.n75 VSUB.n76 55.1435
R906 VSUB.n76 VSUB.n78 121.763
R907 VSUB.n80 VSUB.n81 55.1435
R908 VSUB.n81 VSUB.n83 121.763
R909 VSUB.n85 VSUB.n86 55.1435
R910 VSUB.n86 VSUB.n88 121.763
R911 VSUB.n90 VSUB.n91 55.1435
R912 VSUB.n91 VSUB.n93 121.763
R913 VSUB.n95 VSUB.n96 55.1435
R914 VSUB.n96 VSUB.n98 121.763
R915 VSUB.n100 VSUB.n101 55.1435
R916 VSUB.n101 VSUB.n103 121.763
R917 VSUB.n105 VSUB.n106 55.1435
R918 VSUB.n106 VSUB.n108 121.763
R919 VSUB.n110 VSUB.n111 55.1435
R920 VSUB.n111 VSUB.n113 121.763
R921 VSUB.n115 VSUB.n116 55.1435
R922 VSUB.n116 VSUB.n118 121.763
R923 VSUB.n120 VSUB.n121 55.1435
R924 VSUB.n121 VSUB.n124 121.763
R925 VSUB.n123 VSUB.n124 55.1435
C0 vcasc vdd 0.39014f
C1 vcasc vg 0.70814f
C2 vg vdd 1.36892f
C3 pbias vdd 12.3364f
C4 nout vdd 0.25725f
C5 vdd nu_next 0.3084f
C6 vg pbias 1.44966f
C7 vg nout 2.44611f
C8 nout pbias 2.78751f
C9 pbias nu_next 1.56047f
C10 nout nu_next 0.01501f
C11 vcasc VSUB 0.41936f
C12 vg VSUB 5.89858f
C13 nout VSUB 6.76664f
C14 nu_next VSUB 1.24835f
C15 pbias VSUB 4.24806f
C16 vdd VSUB 83.60265f
C17 vdd.t3 VSUB 0.05765f
C18 vdd.n0 VSUB 0.12515f
C19 vdd.n1 VSUB 0.01889f
C20 vdd.n178 VSUB 0.01229f
C21 vdd.n180 VSUB 0.01918f
C22 vdd.n181 VSUB 0.18185f
C23 vdd.n183 VSUB 0.45464f
C24 vdd.n185 VSUB 0.13102f
C25 vdd.n187 VSUB 0.13102f
C26 vdd.n189 VSUB 0.13102f
C27 vdd.n191 VSUB 0.13102f
C28 vdd.n193 VSUB 0.13102f
C29 vdd.n195 VSUB 0.13102f
C30 vdd.t0 VSUB 0.13102f
C31 vdd.n198 VSUB 0.13102f
C32 vdd.n200 VSUB 0.13102f
C33 vdd.n202 VSUB 0.13102f
C34 vdd.n204 VSUB 0.13102f
C35 vdd.n206 VSUB 0.13102f
C36 vdd.n208 VSUB 0.13102f
C37 vdd.n210 VSUB 0.13102f
C38 vdd.n212 VSUB 0.13102f
C39 vdd.n214 VSUB 0.13102f
C40 vdd.n216 VSUB 0.13102f
C41 vdd.n218 VSUB 0.13102f
C42 vdd.n220 VSUB 0.13102f
C43 vdd.n222 VSUB 0.13102f
C44 vdd.n224 VSUB 0.13102f
C45 vdd.n226 VSUB 0.13102f
C46 vdd.n228 VSUB 0.13102f
C47 vdd.n230 VSUB 0.13102f
C48 vdd.n232 VSUB 0.07861f
C49 vdd.n234 VSUB 0.11792f
C50 vdd.n236 VSUB 0.13102f
C51 vdd.n238 VSUB 0.13102f
C52 vdd.n240 VSUB 0.13102f
C53 vdd.n242 VSUB 0.13102f
C54 vdd.n244 VSUB 0.13102f
C55 vdd.n246 VSUB 0.13102f
C56 vdd.n248 VSUB 0.13102f
C57 vdd.n250 VSUB 0.13102f
C58 vdd.n252 VSUB 0.13102f
C59 vdd.n254 VSUB 0.13102f
C60 vdd.n256 VSUB 0.13102f
C61 vdd.n258 VSUB 0.13102f
C62 vdd.n260 VSUB 0.13102f
C63 vdd.n262 VSUB 0.13102f
C64 vdd.n264 VSUB 0.13102f
C65 vdd.n266 VSUB 0.13102f
C66 vdd.n268 VSUB 0.09172f
C67 vdd.n270 VSUB 0.10482f
C68 vdd.n272 VSUB 0.13102f
C69 vdd.n274 VSUB 0.13102f
C70 vdd.n276 VSUB 0.13102f
C71 vdd.n278 VSUB 0.13102f
C72 vdd.n280 VSUB 0.13102f
C73 vdd.n282 VSUB 0.13102f
C74 vdd.n284 VSUB 0.13102f
C75 vdd.n286 VSUB 0.13102f
C76 vdd.n288 VSUB 0.13102f
C77 vdd.n290 VSUB 0.13102f
C78 vdd.n292 VSUB 0.13102f
C79 vdd.n294 VSUB 0.13102f
C80 vdd.n296 VSUB 0.13102f
C81 vdd.n298 VSUB 0.13102f
C82 vdd.n300 VSUB 0.13102f
C83 vdd.n302 VSUB 0.13102f
C84 vdd.n304 VSUB 0.10482f
C85 vdd.n306 VSUB 0.09172f
C86 vdd.n308 VSUB 0.13102f
C87 vdd.n310 VSUB 0.13102f
C88 vdd.n312 VSUB 0.13102f
C89 vdd.n314 VSUB 0.13102f
C90 vdd.n316 VSUB 0.13102f
C91 vdd.n318 VSUB 0.13102f
C92 vdd.n320 VSUB 0.13102f
C93 vdd.n322 VSUB 0.13102f
C94 vdd.n324 VSUB 0.13102f
C95 vdd.n326 VSUB 0.13102f
C96 vdd.n328 VSUB 0.13102f
C97 vdd.n330 VSUB 0.13102f
C98 vdd.n332 VSUB 0.13102f
C99 vdd.n334 VSUB 0.13102f
C100 vdd.n336 VSUB 0.13102f
C101 vdd.n338 VSUB 0.13102f
C102 vdd.n340 VSUB 0.13102f
C103 vdd.n342 VSUB 0.11792f
C104 vdd.n344 VSUB 0.07861f
C105 vdd.n346 VSUB 0.13102f
C106 vdd.n348 VSUB 0.13102f
C107 vdd.n350 VSUB 0.13102f
C108 vdd.n352 VSUB 0.13102f
C109 vdd.t10 VSUB 0.45464f
C110 vdd.n355 VSUB 0.1822f
C111 vdd.t2 VSUB 0.06551f
C112 vdd.t4 VSUB 0.06551f
C113 vdd.t6 VSUB 0.06551f
C114 vdd.t8 VSUB 0.06551f
C115 vdd.t7 VSUB 0.19615f
C116 vdd.n357 VSUB 0.19817f
C117 vdd.t9 VSUB 0.13168f
C118 vdd.n358 VSUB 0.16062f
C119 vdd.t1 VSUB 0.19615f
C120 vdd.n359 VSUB 0.15388f
C121 vdd.t5 VSUB 0.05765f
C122 nu_next.t0 VSUB 0.25473f
C123 nu_next.n0 VSUB 0.65911f
C124 nu_next.t1 VSUB 0.25473f
C125 nout.t0 VSUB 0.13373f
C126 nout.n0 VSUB 0.43897f
C127 nout.t3 VSUB 0.8213f
C128 nout.t2 VSUB 1.14433f
C129 nout.n1 VSUB 0.32065f
C130 nout.t4 VSUB 1.14433f
C131 nout.n2 VSUB 0.90785f
C132 nout.t1 VSUB 0.13373f
C133 vg.t1 VSUB 0.68089f
C134 vg.t0 VSUB 1.65094f
C135 vg.n0 VSUB 1.66108f
C136 vg.t2 VSUB 1.26507f
C137 a_8800_4360.t0 VSUB 0.66833f
C138 a_8800_4360.t1 VSUB 0.66833f
.ends
