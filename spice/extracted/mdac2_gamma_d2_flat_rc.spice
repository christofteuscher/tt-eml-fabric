* NGSPICE file created from mdac_gamma.ext - technology: sky130A

.subckt mdac_gamma
X0 vdd.t11 vg4.t0 vg4.t1 vdd.t10 sky130_fd_pr__pfet_g5v0d10v5 ad=4.4 pd=9.1 as=4.4 ps=9.1 w=8 l=2
X1 vdd.t9 vg4.t5 a_800_3740.t0 vdd.t8 sky130_fd_pr__pfet_g5v0d10v5 ad=4.4 pd=9.1 as=4.4 ps=9.1 w=8 l=2
X2 a_1980_n2000.t0 vcasc a_4440_600.t1 vdd.t23 sky130_fd_pr__pfet_g5v0d10v5 ad=8.8 pd=18.2 as=4.4 ps=9.1 w=8 l=1
X3 nsum.t0 a0 a_200_n2000.t0 w_50_n4800.t0 sky130_fd_pr__nfet_g5v0d10v5 ad=2.2 pd=5.1 as=4.4 ps=10.2 w=4 l=0.5
X4 nsum.t7 sgn iout_p.t0 w_50_n4800.t21 sky130_fd_pr__nfet_g5v0d10v5 ad=2.2 pd=5.1 as=4.4 ps=10.2 w=4 l=0.5
X5 iout_n.t0 nmir.t3 w_50_n4800.t20 w_50_n4800.t19 sky130_fd_pr__nfet_g5v0d10v5 ad=8.8 pd=18.2 as=4.4 ps=9.1 w=8 l=2
X6 a_1980_n2000.t1 b0 nsum.t5 w_50_n4800.t15 sky130_fd_pr__nfet_g5v0d10v5 ad=4.4 pd=10.2 as=2.2 ps=5.1 w=4 l=0.5
X7 nsum.t1 b1 a_380_3740.t1 w_50_n4800.t11 sky130_fd_pr__nfet_g5v0d10v5 ad=2.2 pd=5.1 as=4.4 ps=10.2 w=4 l=0.5
X8 w_50_n4800.t18 nmir.t1 nmir.t2 w_50_n4800.t17 sky130_fd_pr__nfet_g5v0d10v5 ad=4.4 pd=9.1 as=8.8 ps=18.2 w=8 l=2
X9 nmir.t0 sgnb nsum.t6 w_50_n4800.t16 sky130_fd_pr__nfet_g5v0d10v5 ad=4.4 pd=10.2 as=2.2 ps=5.1 w=4 l=0.5
X10 a_420_n4440.t0 vcasc a_4620_3740.t1 vdd.t19 sky130_fd_pr__pfet_g5v0d10v5 ad=8.8 pd=18.2 as=4.4 ps=9.1 w=8 l=1
X11 a_2460_3740.t0 vcasc a_2040_3740.t1 vdd.t17 sky130_fd_pr__pfet_g5v0d10v5 ad=8.8 pd=18.2 as=4.4 ps=9.1 w=8 l=1
X12 a_840_n2000.t1 a1 nsum.t3 w_50_n4800.t13 sky130_fd_pr__nfet_g5v0d10v5 ad=4.4 pd=10.2 as=2.2 ps=5.1 w=4 l=0.5
X13 a_2460_3740.t1 b1 nsum.t2 w_50_n4800.t12 sky130_fd_pr__nfet_g5v0d10v5 ad=4.4 pd=10.2 as=2.2 ps=5.1 w=4 l=0.5
X14 a_4620_3740.t0 vg vdd.t5 vdd.t4 sky130_fd_pr__pfet_g5v0d10v5 ad=4.4 pd=9.1 as=4.4 ps=9.1 w=8 l=2
X15 a_620_600.t1 vcasc a_200_n2000.t1 vdd.t20 sky130_fd_pr__pfet_g5v0d10v5 ad=4.4 pd=9.1 as=8.8 ps=18.2 w=8 l=1
X16 a_4440_600.t0 vg4.t3 vdd.t15 vdd.t14 sky130_fd_pr__pfet_g5v0d10v5 ad=4.4 pd=9.1 as=4.4 ps=9.1 w=8 l=2
X17 a_1860_600.t0 vg vdd.t1 vdd.t0 sky130_fd_pr__pfet_g5v0d10v5 ad=4.4 pd=9.1 as=4.4 ps=9.1 w=8 l=2
X18 a_420_n4440.t8 a_420_n4440.t7 w_50_n4800.t8 w_50_n4800.t7 sky130_fd_pr__nfet_g5v0d10v5 ad=4.4 pd=9.1 as=4.4 ps=9.1 w=8 l=2
X19 vdd.t3 vg a_620_600.t0 vdd.t2 sky130_fd_pr__pfet_g5v0d10v5 ad=4.4 pd=9.1 as=4.4 ps=9.1 w=8 l=2
X20 a_3200_600.t1 vcasc a_1340_n2000.t0 vdd.t22 sky130_fd_pr__pfet_g5v0d10v5 ad=4.4 pd=9.1 as=8.8 ps=18.2 w=8 l=1
X21 a_800_3740.t1 vcasc a_380_3740.t0 vdd.t16 sky130_fd_pr__pfet_g5v0d10v5 ad=4.4 pd=9.1 as=8.8 ps=18.2 w=8 l=1
X22 w_50_n4800.t6 a_420_n4440.t3 a_420_n4440.t4 w_50_n4800.t5 sky130_fd_pr__nfet_g5v0d10v5 ad=4.4 pd=9.1 as=4.4 ps=9.1 w=8 l=2
X23 a_420_n4440.t2 a_420_n4440.t1 w_50_n4800.t4 w_50_n4800.t3 sky130_fd_pr__nfet_g5v0d10v5 ad=4.4 pd=9.1 as=4.4 ps=9.1 w=8 l=2
X24 a_840_n2000.t0 vcasc a_1860_600.t1 vdd.t21 sky130_fd_pr__pfet_g5v0d10v5 ad=8.8 pd=18.2 as=4.4 ps=9.1 w=8 l=1
X25 vg4.t2 vcasc a_200_n4240.t0 vdd.t18 sky130_fd_pr__pfet_g5v0d10v5 ad=4.4 pd=9.1 as=8.8 ps=18.2 w=8 l=1
X26 w_50_n4800.t10 a_420_n4440.t5 a_420_n4440.t6 w_50_n4800.t9 sky130_fd_pr__nfet_g5v0d10v5 ad=8.8 pd=18.2 as=4.4 ps=9.1 w=8 l=2
X27 nsum.t4 a1 a_1340_n2000.t1 w_50_n4800.t14 sky130_fd_pr__nfet_g5v0d10v5 ad=2.2 pd=5.1 as=4.4 ps=10.2 w=4 l=0.5
X28 vdd.t7 vg a_3200_600.t0 vdd.t6 sky130_fd_pr__pfet_g5v0d10v5 ad=4.4 pd=9.1 as=4.4 ps=9.1 w=8 l=2
X29 w_50_n4800.t2 a_420_n4440.t9 a_200_n4240.t1 w_50_n4800.t1 sky130_fd_pr__nfet_g5v0d10v5 ad=4.4 pd=9.1 as=8.8 ps=18.2 w=8 l=2
X30 a_2040_3740.t0 vg4.t4 vdd.t13 vdd.t12 sky130_fd_pr__pfet_g5v0d10v5 ad=4.4 pd=9.1 as=4.4 ps=9.1 w=8 l=2
R0 iout_n.t0 iout_n 33.6865
R1 nmir nmir.t0 64.3191
R2 nmir nmir.n0 0.46925
R3 nmir.n0 nmir.t1 278.053
R4 nmir.n0 nmir.t3 279.022
R5 nmir nmir.t2 26.6488
R6 iout_p iout_p.t0 44.3316
R7 nsum.t0 nsum.n0 15.6755
R8 nsum.n0 nsum.t3 15.6755
R9 nsum nsum.n0 33.2191
R10 nsum nsum.n2 4.0685
R11 nsum.n2 nsum.n4 0.6585
R12 nsum.n4 nsum.n5 37.2871
R13 nsum.n5 nsum.t7 15.6755
R14 nsum.n5 nsum.t6 15.6755
R15 nsum.n4 nsum.n3 36.6291
R16 nsum.n3 nsum.t1 15.6755
R17 nsum.n3 nsum.t2 15.6755
R18 nsum.n2 nsum.n1 36.6291
R19 nsum.n1 nsum.t4 15.6755
R20 nsum.n1 nsum.t5 15.6755
R21 a_1980_n2000.t1 a_1980_n2000.t0 126.457
R22 a_4440_600.t0 a_4440_600.t1 26.263
R23 a_3200_600.t0 a_3200_600.t1 26.263
R24 a_1340_n2000.t1 a_1340_n2000.t0 124.05
R25 a_840_n2000.t1 a_840_n2000.t0 123.894
R26 a_1860_600.t0 a_1860_600.t1 26.263
R27 a_620_600.t0 a_620_600.t1 26.263
R28 a_200_n2000.t0 a_200_n2000.t1 121.519
R29 a_420_n4440.t0 a_420_n4440.n7 74.4442
R30 a_420_n4440.n7 a_420_n4440.n1 0.2355
R31 a_420_n4440.n5 a_420_n4440.n6 0.36475
R32 a_420_n4440.n1 a_420_n4440.n5 0.17675
R33 a_420_n4440.n6 a_420_n4440.t3 281.358
R34 a_420_n4440.n5 a_420_n4440.t7 281.358
R35 a_420_n4440.n6 a_420_n4440.n3 0.17675
R36 a_420_n4440.n3 a_420_n4440.n4 0.17675
R37 a_420_n4440.n4 a_420_n4440.t9 281.721
R38 a_420_n4440.n4 a_420_n4440.t1 281.358
R39 a_420_n4440.n3 a_420_n4440.n2 22.2525
R40 a_420_n4440.n2 a_420_n4440.t2 7.838
R41 a_420_n4440.n2 a_420_n4440.t4 7.838
R42 a_420_n4440.n1 a_420_n4440.n0 22.2525
R43 a_420_n4440.n0 a_420_n4440.t8 7.838
R44 a_420_n4440.n0 a_420_n4440.t6 7.838
R45 a_420_n4440.n7 a_420_n4440.t5 281.276
R46 a_4620_3740.t0 a_4620_3740.t1 26.263
R47 a_200_n4240.t0 a_200_n4240.t1 105.624
R48 a_2460_3740.t1 a_2460_3740.t0 125.144
R49 a_2040_3740.t0 a_2040_3740.t1 26.263
R50 a_800_3740.t0 a_800_3740.t1 26.263
R51 a_380_3740.t1 a_380_3740.t0 127.239
R52 vg4.n0 vg4.t2 13.1318
R53 vg4.n0 vg4.t1 13.1318
R54 vg4.n3 vg4.n0 52.3388
R55 vg4.n2 vg4.n3 0.453625
R56 vg4 vg4.n2 20.161
R57 vg4 vg4.t3 285.209
R58 vg4.n2 vg4.t0 285.209
R59 vg4.n3 vg4.n1 2.54738
R60 vg4 vg4.n1 0.938
R61 vg4.t5 vg4 285.209
R62 vg4.n1 vg4.t4 285.209
R63 vdd.n0 vdd.t11 13.1318
R64 vdd.n0 vdd.t5 13.1318
R65 vdd vdd.n0 41.2309
R66 vdd vdd.n383 0.016125
R67 vdd.n1 vdd.n2 4.28224
R68 vdd.n4 vdd.n3 9.3005
R69 vdd.n6 vdd.n5 9.3005
R70 vdd.n8 vdd.n7 9.3005
R71 vdd.n10 vdd.n9 9.3005
R72 vdd.n12 vdd.n11 9.3005
R73 vdd.n14 vdd.n13 9.3005
R74 vdd.n16 vdd.n15 9.3005
R75 vdd.n18 vdd.n17 9.3005
R76 vdd.n20 vdd.n19 9.3005
R77 vdd.n22 vdd.n21 9.3005
R78 vdd.n25 vdd.n23 9.3005
R79 vdd.n27 vdd.n26 9.3005
R80 vdd.n29 vdd.n28 9.3005
R81 vdd.n31 vdd.n30 9.3005
R82 vdd.n33 vdd.n32 9.3005
R83 vdd.n35 vdd.n34 9.3005
R84 vdd.n37 vdd.n36 9.3005
R85 vdd.n39 vdd.n38 9.3005
R86 vdd.n41 vdd.n40 9.3005
R87 vdd.n43 vdd.n42 9.3005
R88 vdd.n45 vdd.n44 9.3005
R89 vdd.n47 vdd.n46 9.3005
R90 vdd.n49 vdd.n48 9.3005
R91 vdd.n51 vdd.n50 9.3005
R92 vdd.n53 vdd.n52 9.3005
R93 vdd.n55 vdd.n54 9.3005
R94 vdd.n57 vdd.n56 9.3005
R95 vdd.n59 vdd.n58 9.3005
R96 vdd.n61 vdd.n60 9.3005
R97 vdd.n63 vdd.n62 9.3005
R98 vdd.n65 vdd.n64 9.3005
R99 vdd.n67 vdd.n66 9.3005
R100 vdd.n69 vdd.n68 9.3005
R101 vdd.n71 vdd.n70 9.3005
R102 vdd.n73 vdd.n72 9.3005
R103 vdd.n75 vdd.n74 9.3005
R104 vdd.n77 vdd.n76 9.3005
R105 vdd.n79 vdd.n78 9.3005
R106 vdd.n81 vdd.n80 9.3005
R107 vdd.n83 vdd.n82 9.3005
R108 vdd.n85 vdd.n84 9.3005
R109 vdd.n87 vdd.n86 9.3005
R110 vdd.n89 vdd.n88 9.3005
R111 vdd.n91 vdd.n90 9.3005
R112 vdd.n93 vdd.n92 9.3005
R113 vdd.n95 vdd.n94 4.28224
R114 vdd.n4 vdd.n1 2.68753
R115 vdd.n6 vdd.n4 0.15675
R116 vdd.n8 vdd.n6 0.15675
R117 vdd.n10 vdd.n8 0.15675
R118 vdd.n12 vdd.n10 0.15675
R119 vdd.n14 vdd.n12 0.15675
R120 vdd.n16 vdd.n14 0.15675
R121 vdd.n18 vdd.n16 0.15675
R122 vdd.n20 vdd.n18 0.15675
R123 vdd.n22 vdd.n20 0.15675
R124 vdd.n25 vdd.n22 0.15675
R125 vdd.n27 vdd.n25 0.15675
R126 vdd.n29 vdd.n27 0.15675
R127 vdd.n31 vdd.n29 0.15675
R128 vdd.n33 vdd.n31 0.15675
R129 vdd.n35 vdd.n33 0.15675
R130 vdd.n37 vdd.n35 0.15675
R131 vdd.n39 vdd.n37 0.15675
R132 vdd.n41 vdd.n39 0.15675
R133 vdd.n43 vdd.n41 0.15675
R134 vdd.n45 vdd.n43 0.15675
R135 vdd.n47 vdd.n45 0.15675
R136 vdd.n49 vdd.n47 0.15675
R137 vdd.n51 vdd.n49 0.15675
R138 vdd.n53 vdd.n51 0.15675
R139 vdd.n55 vdd.n53 0.15675
R140 vdd.n57 vdd.n55 0.15675
R141 vdd.n59 vdd.n57 0.15675
R142 vdd.n61 vdd.n59 0.15675
R143 vdd.n63 vdd.n61 0.15675
R144 vdd.n65 vdd.n63 0.15675
R145 vdd.n67 vdd.n65 0.15675
R146 vdd.n69 vdd.n67 0.15675
R147 vdd.n71 vdd.n69 0.15675
R148 vdd.n73 vdd.n71 0.15675
R149 vdd.n75 vdd.n73 0.15675
R150 vdd.n383 vdd.n75 0.1255
R151 vdd.n383 vdd.n77 0.03175
R152 vdd.n77 vdd.n79 0.15675
R153 vdd.n79 vdd.n81 0.15675
R154 vdd.n81 vdd.n83 0.15675
R155 vdd.n83 vdd.n85 0.15675
R156 vdd.n85 vdd.n87 0.15675
R157 vdd.n87 vdd.n89 0.15675
R158 vdd.n89 vdd.n91 0.15675
R159 vdd.n91 vdd.n93 0.15675
R160 vdd.n93 vdd.n95 2.68753
R161 vdd.n97 vdd.n96 185
R162 vdd.n99 vdd.n98 185
R163 vdd.n2 vdd.n99 185
R164 vdd.n101 vdd.n100 185
R165 vdd.n3 vdd.n101 185
R166 vdd.n103 vdd.n102 185
R167 vdd.n5 vdd.n103 185
R168 vdd.n105 vdd.n104 185
R169 vdd.n7 vdd.n105 185
R170 vdd.n107 vdd.n106 185
R171 vdd.n9 vdd.n107 185
R172 vdd.n109 vdd.n108 185
R173 vdd.n11 vdd.n109 185
R174 vdd.n111 vdd.n110 185
R175 vdd.n13 vdd.n111 185
R176 vdd.n113 vdd.n112 185
R177 vdd.n15 vdd.n113 185
R178 vdd.n115 vdd.n114 185
R179 vdd.n17 vdd.n115 185
R180 vdd.n117 vdd.n116 185
R181 vdd.n19 vdd.n117 185
R182 vdd.n119 vdd.n118 185
R183 vdd.n21 vdd.n119 185
R184 vdd.n121 vdd.n120 185
R185 vdd.n23 vdd.n121 185
R186 vdd.n123 vdd.n122 185
R187 vdd.n26 vdd.n123 185
R188 vdd.n125 vdd.n124 185
R189 vdd.n28 vdd.n125 185
R190 vdd.n127 vdd.n126 185
R191 vdd.n30 vdd.n127 185
R192 vdd.n129 vdd.n128 185
R193 vdd.n32 vdd.n129 185
R194 vdd.n131 vdd.n130 185
R195 vdd.n34 vdd.n131 185
R196 vdd.n133 vdd.n132 185
R197 vdd.n36 vdd.n133 185
R198 vdd.n135 vdd.n134 185
R199 vdd.n38 vdd.n135 185
R200 vdd.n137 vdd.n136 185
R201 vdd.n40 vdd.n137 185
R202 vdd.n139 vdd.n138 185
R203 vdd.n42 vdd.n139 185
R204 vdd.n141 vdd.n140 185
R205 vdd.n44 vdd.n141 185
R206 vdd.n143 vdd.n142 185
R207 vdd.n46 vdd.n143 185
R208 vdd.n145 vdd.n144 185
R209 vdd.n48 vdd.n145 185
R210 vdd.n147 vdd.n146 185
R211 vdd.n50 vdd.n147 185
R212 vdd.n149 vdd.n148 185
R213 vdd.n52 vdd.n149 185
R214 vdd.n151 vdd.n150 185
R215 vdd.n54 vdd.n151 185
R216 vdd.n153 vdd.n152 185
R217 vdd.n56 vdd.n153 185
R218 vdd.n155 vdd.n154 185
R219 vdd.n58 vdd.n155 185
R220 vdd.n157 vdd.n156 185
R221 vdd.n60 vdd.n157 185
R222 vdd.n159 vdd.n158 185
R223 vdd.n62 vdd.n159 185
R224 vdd.n161 vdd.n160 185
R225 vdd.n64 vdd.n161 185
R226 vdd.n163 vdd.n162 185
R227 vdd.n66 vdd.n163 185
R228 vdd.n165 vdd.n164 185
R229 vdd.n68 vdd.n165 185
R230 vdd.n167 vdd.n166 185
R231 vdd.n70 vdd.n167 185
R232 vdd.n169 vdd.n168 185
R233 vdd.n72 vdd.n169 185
R234 vdd.n171 vdd.n170 185
R235 vdd.n74 vdd.n171 185
R236 vdd.n173 vdd.n172 185
R237 vdd.n76 vdd.n173 185
R238 vdd.n175 vdd.n174 185
R239 vdd.n78 vdd.n175 185
R240 vdd.n177 vdd.n176 185
R241 vdd.n80 vdd.n177 185
R242 vdd.n179 vdd.n178 185
R243 vdd.n82 vdd.n179 185
R244 vdd.n181 vdd.n180 185
R245 vdd.n84 vdd.n181 185
R246 vdd.n182 vdd.n183 185
R247 vdd.n86 vdd.n183 185
R248 vdd.n184 vdd.n185 185
R249 vdd.n88 vdd.n185 185
R250 vdd.n186 vdd.n187 185
R251 vdd.n90 vdd.n187 185
R252 vdd.n188 vdd.n189 185
R253 vdd.n92 vdd.n189 185
R254 vdd.n94 vdd.n191 185
R255 vdd.n190 vdd.n95 235.05
R256 vdd.n1 vdd.n97 189.355
R257 vdd.n2 vdd.n3 16.0005
R258 vdd.n3 vdd.n5 16.0005
R259 vdd.n5 vdd.n7 16.0005
R260 vdd.n7 vdd.n9 16.0005
R261 vdd.n9 vdd.n11 16.0005
R262 vdd.n11 vdd.n13 16.0005
R263 vdd.n13 vdd.n15 16.0005
R264 vdd.n15 vdd.n17 16.0005
R265 vdd.n17 vdd.n19 16.0005
R266 vdd.n19 vdd.n21 16.0005
R267 vdd.n21 vdd.n23 16.0005
R268 vdd.n23 vdd.n26 16.0005
R269 vdd.n26 vdd.n28 16.0005
R270 vdd.n28 vdd.n30 16.0005
R271 vdd.n30 vdd.n32 16.0005
R272 vdd.n32 vdd.n34 16.0005
R273 vdd.n34 vdd.n36 16.0005
R274 vdd.n36 vdd.n38 16.0005
R275 vdd.n38 vdd.n40 16.0005
R276 vdd.n40 vdd.n42 16.0005
R277 vdd.n42 vdd.n44 16.0005
R278 vdd.n44 vdd.n46 16.0005
R279 vdd.n46 vdd.n48 16.0005
R280 vdd.n48 vdd.n50 16.0005
R281 vdd.n50 vdd.n52 16.0005
R282 vdd.n52 vdd.n54 16.0005
R283 vdd.n54 vdd.n56 16.0005
R284 vdd.n56 vdd.n58 16.0005
R285 vdd.n58 vdd.n60 16.0005
R286 vdd.n60 vdd.n62 16.0005
R287 vdd.n62 vdd.n64 16.0005
R288 vdd.n64 vdd.n66 16.0005
R289 vdd.n66 vdd.n68 16.0005
R290 vdd.n68 vdd.n70 16.0005
R291 vdd.n70 vdd.n72 16.0005
R292 vdd.n72 vdd.n74 16.0005
R293 vdd.n74 vdd.n76 16.0005
R294 vdd.n76 vdd.n78 16.0005
R295 vdd.n78 vdd.n80 16.0005
R296 vdd.n80 vdd.n82 16.0005
R297 vdd.n82 vdd.n84 16.0005
R298 vdd.n84 vdd.n86 16.0005
R299 vdd.n86 vdd.n88 16.0005
R300 vdd.n88 vdd.n90 16.0005
R301 vdd.n90 vdd.n92 16.0005
R302 vdd.n92 vdd.n94 16.0005
R303 vdd.n97 vdd.n99 114.001
R304 vdd.n99 vdd.n101 114.001
R305 vdd.n101 vdd.n103 114.001
R306 vdd.n103 vdd.n105 114.001
R307 vdd.n105 vdd.n107 114.001
R308 vdd.n107 vdd.n109 114.001
R309 vdd.n109 vdd.n111 114.001
R310 vdd.n111 vdd.n113 114.001
R311 vdd.n113 vdd.n115 114.001
R312 vdd.n115 vdd.n117 114.001
R313 vdd.n117 vdd.n119 114.001
R314 vdd.n119 vdd.n121 114.001
R315 vdd.n121 vdd.n123 114.001
R316 vdd.n123 vdd.n125 114.001
R317 vdd.n125 vdd.n127 114.001
R318 vdd.n127 vdd.n129 114.001
R319 vdd.n129 vdd.n131 114.001
R320 vdd.n131 vdd.n133 114.001
R321 vdd.n133 vdd.n135 114.001
R322 vdd.n135 vdd.n137 114.001
R323 vdd.n137 vdd.n139 114.001
R324 vdd.n139 vdd.n141 114.001
R325 vdd.n141 vdd.n143 114.001
R326 vdd.n143 vdd.n145 114.001
R327 vdd.n145 vdd.n147 114.001
R328 vdd.n147 vdd.n149 114.001
R329 vdd.n149 vdd.n151 114.001
R330 vdd.n151 vdd.n153 114.001
R331 vdd.n153 vdd.n155 114.001
R332 vdd.n155 vdd.n157 114.001
R333 vdd.n157 vdd.n159 114.001
R334 vdd.n159 vdd.n161 114.001
R335 vdd.n161 vdd.n163 114.001
R336 vdd.n163 vdd.n165 114.001
R337 vdd.n165 vdd.n167 114.001
R338 vdd.n167 vdd.n169 114.001
R339 vdd.n169 vdd.n171 114.001
R340 vdd.n171 vdd.n173 114.001
R341 vdd.n173 vdd.n175 114.001
R342 vdd.n175 vdd.n177 114.001
R343 vdd.n177 vdd.n179 114.001
R344 vdd.n179 vdd.n181 114.001
R345 vdd.n181 vdd.n183 114.001
R346 vdd.n183 vdd.n185 114.001
R347 vdd.n185 vdd.n187 114.001
R348 vdd.n187 vdd.n189 114.001
R349 vdd.n189 vdd.n191 114.001
R350 vdd.n191 vdd.n190 42.2629
R351 vdd.n192 vdd.n193 185
R352 vdd.n194 vdd.n195 185
R353 vdd.n195 vdd.n196 185
R354 vdd.n197 vdd.n198 185
R355 vdd.n198 vdd.n199 185
R356 vdd.n200 vdd.n201 185
R357 vdd.n201 vdd.n202 185
R358 vdd.n203 vdd.n204 185
R359 vdd.n204 vdd.n205 185
R360 vdd.n206 vdd.n207 185
R361 vdd.n207 vdd.n208 185
R362 vdd.n209 vdd.n210 185
R363 vdd.n210 vdd.n211 185
R364 vdd.n212 vdd.n213 185
R365 vdd.n213 vdd.n214 185
R366 vdd.n215 vdd.n216 185
R367 vdd.n216 vdd.n217 185
R368 vdd.n218 vdd.n219 185
R369 vdd.n219 vdd.n220 185
R370 vdd.n221 vdd.n222 185
R371 vdd.n222 vdd.n223 185
R372 vdd.n224 vdd.n225 185
R373 vdd.n225 vdd.n226 185
R374 vdd.n227 vdd.n228 185
R375 vdd.n228 vdd.n229 185
R376 vdd.n230 vdd.n231 185
R377 vdd.n231 vdd.n232 185
R378 vdd.n233 vdd.n234 185
R379 vdd.n234 vdd.n235 185
R380 vdd.n236 vdd.n237 185
R381 vdd.n237 vdd.n238 185
R382 vdd.n239 vdd.n240 185
R383 vdd.n240 vdd.n241 185
R384 vdd.n242 vdd.n243 185
R385 vdd.n243 vdd.n244 185
R386 vdd.n245 vdd.n246 185
R387 vdd.n246 vdd.n247 185
R388 vdd.n248 vdd.n249 185
R389 vdd.n249 vdd.n250 185
R390 vdd.n251 vdd.n252 185
R391 vdd.n252 vdd.n253 185
R392 vdd.n254 vdd.n255 185
R393 vdd.n255 vdd.n256 185
R394 vdd.n257 vdd.n258 185
R395 vdd.n258 vdd.n259 185
R396 vdd.n260 vdd.n261 185
R397 vdd.n261 vdd.n262 185
R398 vdd.n263 vdd.n264 185
R399 vdd.n264 vdd.n265 185
R400 vdd.n266 vdd.n267 185
R401 vdd.n267 vdd.n268 185
R402 vdd.n269 vdd.n270 185
R403 vdd.n270 vdd.n271 185
R404 vdd.n272 vdd.n273 185
R405 vdd.n273 vdd.n274 185
R406 vdd.n275 vdd.n276 185
R407 vdd.n276 vdd.n277 185
R408 vdd.n278 vdd.n279 185
R409 vdd.n279 vdd.n280 185
R410 vdd.n281 vdd.n282 185
R411 vdd.n282 vdd.n283 185
R412 vdd.n284 vdd.n285 185
R413 vdd.n285 vdd.n286 185
R414 vdd.n287 vdd.n288 185
R415 vdd.n288 vdd.n289 185
R416 vdd.n290 vdd.n291 185
R417 vdd.n291 vdd.n292 185
R418 vdd.n293 vdd.n294 185
R419 vdd.n294 vdd.n295 185
R420 vdd.n296 vdd.n297 185
R421 vdd.n297 vdd.n298 185
R422 vdd.n299 vdd.n300 185
R423 vdd.n300 vdd.n301 185
R424 vdd.n302 vdd.n303 185
R425 vdd.n303 vdd.n304 185
R426 vdd.n305 vdd.n306 185
R427 vdd.n306 vdd.n307 185
R428 vdd.n308 vdd.n309 185
R429 vdd.n309 vdd.n310 185
R430 vdd.n311 vdd.n312 185
R431 vdd.n312 vdd.n313 185
R432 vdd.n314 vdd.n315 185
R433 vdd.n315 vdd.n316 185
R434 vdd.n317 vdd.n318 185
R435 vdd.n318 vdd.n319 185
R436 vdd.n320 vdd.n321 185
R437 vdd.n321 vdd.n322 185
R438 vdd.n323 vdd.n324 185
R439 vdd.n324 vdd.n325 185
R440 vdd.n326 vdd.n327 185
R441 vdd.n327 vdd.n328 185
R442 vdd.n329 vdd.n330 185
R443 vdd.n330 vdd.n331 185
R444 vdd.n96 vdd.n332 191.013
R445 vdd.n96 vdd.n329 9.01949
R446 vdd.n98 vdd.n329 6.01316
R447 vdd.n98 vdd.n326 9.01949
R448 vdd.t20 vdd.n326 4.50999
R449 vdd.n100 vdd.t20 1.50366
R450 vdd.n100 vdd.n323 9.01949
R451 vdd.n102 vdd.n323 6.01316
R452 vdd.n102 vdd.n320 9.01949
R453 vdd.t16 vdd.n320 1.50366
R454 vdd.n104 vdd.t16 4.50999
R455 vdd.n104 vdd.n317 9.01949
R456 vdd.n106 vdd.n317 6.01316
R457 vdd.n106 vdd.n314 9.01949
R458 vdd.n108 vdd.n314 6.01316
R459 vdd.n108 vdd.n311 9.01949
R460 vdd.n110 vdd.n311 6.01316
R461 vdd.n110 vdd.t2 1.50366
R462 vdd.t2 vdd.n308 7.51632
R463 vdd.n112 vdd.n308 6.01316
R464 vdd.n112 vdd.n305 9.01949
R465 vdd.t8 vdd.n305 4.50999
R466 vdd.n114 vdd.t8 1.50366
R467 vdd.n114 vdd.n302 9.01949
R468 vdd.n116 vdd.n302 6.01316
R469 vdd.n116 vdd.n299 9.01949
R470 vdd.n118 vdd.n299 6.01316
R471 vdd.n118 vdd.n296 9.01949
R472 vdd.n120 vdd.n296 6.01316
R473 vdd.n120 vdd.n293 9.01949
R474 vdd.n122 vdd.n293 6.01316
R475 vdd.n122 vdd.t0 4.50999
R476 vdd.t0 vdd.n290 4.50999
R477 vdd.n124 vdd.n290 6.01316
R478 vdd.n124 vdd.n287 9.01949
R479 vdd.n126 vdd.n287 6.01316
R480 vdd.n126 vdd.t12 1.50366
R481 vdd.t12 vdd.n284 7.51632
R482 vdd.n128 vdd.n284 6.01316
R483 vdd.n128 vdd.n281 9.01949
R484 vdd.n130 vdd.n281 6.01316
R485 vdd.n130 vdd.n278 9.01949
R486 vdd.n132 vdd.n278 6.01316
R487 vdd.n132 vdd.t21 7.51632
R488 vdd.n275 vdd.t21 1.50366
R489 vdd.n134 vdd.n275 6.01316
R490 vdd.n134 vdd.n272 9.01949
R491 vdd.n136 vdd.n272 6.01316
R492 vdd.n136 vdd.t17 4.50999
R493 vdd.t17 vdd.n269 4.50999
R494 vdd.n138 vdd.n269 6.01316
R495 vdd.n138 vdd.n266 9.01949
R496 vdd.n140 vdd.n266 6.01316
R497 vdd.n140 vdd.n263 9.01949
R498 vdd.n142 vdd.n263 6.01316
R499 vdd.n142 vdd.n260 9.01949
R500 vdd.n144 vdd.n260 6.01316
R501 vdd.n144 vdd.n257 9.01949
R502 vdd.n146 vdd.n257 6.01316
R503 vdd.n146 vdd.n254 9.01949
R504 vdd.n148 vdd.n254 6.01316
R505 vdd.n148 vdd.n251 9.01949
R506 vdd.n150 vdd.n251 6.01316
R507 vdd.n150 vdd.n248 9.01949
R508 vdd.t22 vdd.n248 1.50366
R509 vdd.n152 vdd.t22 4.50999
R510 vdd.n152 vdd.n245 9.01949
R511 vdd.n154 vdd.n245 6.01316
R512 vdd.n154 vdd.t18 7.51632
R513 vdd.n242 vdd.t18 1.50366
R514 vdd.n156 vdd.n242 6.01316
R515 vdd.n156 vdd.n239 9.01949
R516 vdd.n158 vdd.n239 6.01316
R517 vdd.n158 vdd.n236 9.01949
R518 vdd.n160 vdd.n236 6.01316
R519 vdd.n160 vdd.n233 9.01949
R520 vdd.t6 vdd.n233 4.50999
R521 vdd.n162 vdd.t6 1.50366
R522 vdd.n162 vdd.n230 9.01949
R523 vdd.n164 vdd.n230 6.01316
R524 vdd.n164 vdd.n227 9.01949
R525 vdd.t10 vdd.n227 1.50366
R526 vdd.n166 vdd.t10 4.50999
R527 vdd.n166 vdd.n224 9.01949
R528 vdd.n168 vdd.n224 6.01316
R529 vdd.n168 vdd.n221 9.01949
R530 vdd.n170 vdd.n221 6.01316
R531 vdd.n170 vdd.n218 9.01949
R532 vdd.n172 vdd.n218 6.01316
R533 vdd.n172 vdd.n215 9.01949
R534 vdd.n174 vdd.n215 6.01316
R535 vdd.n174 vdd.t14 1.50366
R536 vdd.t14 vdd.n212 7.51632
R537 vdd.n176 vdd.n212 6.01316
R538 vdd.n176 vdd.n209 9.01949
R539 vdd.t4 vdd.n209 4.50999
R540 vdd.n178 vdd.t4 1.50366
R541 vdd.n178 vdd.n206 9.01949
R542 vdd.n180 vdd.n206 6.01316
R543 vdd.n180 vdd.n203 9.01949
R544 vdd.n182 vdd.n203 6.01316
R545 vdd.n200 vdd.n182 9.01949
R546 vdd.n184 vdd.n200 6.01316
R547 vdd.t23 vdd.n184 4.50999
R548 vdd.n197 vdd.t23 4.50999
R549 vdd.n186 vdd.n197 6.01316
R550 vdd.n194 vdd.n186 9.01949
R551 vdd.n188 vdd.n194 6.01316
R552 vdd.t19 vdd.n188 1.50366
R553 vdd.n192 vdd.t19 7.51632
R554 vdd.n190 vdd.n192 80.169
R555 vdd.n334 vdd.n331 4.28224
R556 vdd.n335 vdd.n328 9.3005
R557 vdd.n336 vdd.n325 9.3005
R558 vdd.n337 vdd.n322 9.3005
R559 vdd.n338 vdd.n319 9.3005
R560 vdd.n339 vdd.n316 9.3005
R561 vdd.n340 vdd.n313 9.3005
R562 vdd.n341 vdd.n310 9.3005
R563 vdd.n342 vdd.n307 9.3005
R564 vdd.n343 vdd.n304 9.3005
R565 vdd.n344 vdd.n301 9.3005
R566 vdd.n345 vdd.n298 9.3005
R567 vdd.n346 vdd.n295 9.3005
R568 vdd.n347 vdd.n292 9.3005
R569 vdd.n348 vdd.n289 9.3005
R570 vdd.n349 vdd.n286 9.3005
R571 vdd.n350 vdd.n283 9.3005
R572 vdd.n351 vdd.n280 9.3005
R573 vdd.n352 vdd.n277 9.3005
R574 vdd.n353 vdd.n274 9.3005
R575 vdd.n354 vdd.n271 9.3005
R576 vdd.n355 vdd.n268 9.3005
R577 vdd.n356 vdd.n265 9.3005
R578 vdd.n357 vdd.n262 9.3005
R579 vdd.n358 vdd.n259 9.3005
R580 vdd.n359 vdd.n256 9.3005
R581 vdd.n360 vdd.n253 9.3005
R582 vdd.n361 vdd.n250 9.3005
R583 vdd.n362 vdd.n247 9.3005
R584 vdd.n363 vdd.n244 9.3005
R585 vdd.n364 vdd.n241 9.3005
R586 vdd.n365 vdd.n238 9.3005
R587 vdd.n366 vdd.n235 9.3005
R588 vdd.n367 vdd.n232 9.3005
R589 vdd.n368 vdd.n229 9.3005
R590 vdd.n369 vdd.n226 9.3005
R591 vdd.n370 vdd.n223 9.3005
R592 vdd.n371 vdd.n220 9.3005
R593 vdd.n372 vdd.n217 9.3005
R594 vdd.n373 vdd.n214 9.3005
R595 vdd.n374 vdd.n211 9.3005
R596 vdd.n375 vdd.n208 9.3005
R597 vdd.n376 vdd.n205 9.3005
R598 vdd.n377 vdd.n202 9.3005
R599 vdd.n378 vdd.n199 9.3005
R600 vdd.n333 vdd.n196 4.28224
R601 vdd.n332 vdd.n334 189.355
R602 vdd.n331 vdd.n328 16.0005
R603 vdd.n328 vdd.n325 16.0005
R604 vdd.n325 vdd.n322 16.0005
R605 vdd.n322 vdd.n319 16.0005
R606 vdd.n319 vdd.n316 16.0005
R607 vdd.n316 vdd.n313 16.0005
R608 vdd.n313 vdd.n310 16.0005
R609 vdd.n310 vdd.n307 16.0005
R610 vdd.n307 vdd.n304 16.0005
R611 vdd.n304 vdd.n301 16.0005
R612 vdd.n301 vdd.n298 16.0005
R613 vdd.n298 vdd.n295 16.0005
R614 vdd.n295 vdd.n292 16.0005
R615 vdd.n292 vdd.n289 16.0005
R616 vdd.n289 vdd.n286 16.0005
R617 vdd.n286 vdd.n283 16.0005
R618 vdd.n283 vdd.n280 16.0005
R619 vdd.n280 vdd.n277 16.0005
R620 vdd.n277 vdd.n274 16.0005
R621 vdd.n274 vdd.n271 16.0005
R622 vdd.n271 vdd.n268 16.0005
R623 vdd.n268 vdd.n265 16.0005
R624 vdd.n265 vdd.n262 16.0005
R625 vdd.n262 vdd.n259 16.0005
R626 vdd.n259 vdd.n256 16.0005
R627 vdd.n256 vdd.n253 16.0005
R628 vdd.n253 vdd.n250 16.0005
R629 vdd.n250 vdd.n247 16.0005
R630 vdd.n247 vdd.n244 16.0005
R631 vdd.n244 vdd.n241 16.0005
R632 vdd.n241 vdd.n238 16.0005
R633 vdd.n238 vdd.n235 16.0005
R634 vdd.n235 vdd.n232 16.0005
R635 vdd.n232 vdd.n229 16.0005
R636 vdd.n229 vdd.n226 16.0005
R637 vdd.n226 vdd.n223 16.0005
R638 vdd.n223 vdd.n220 16.0005
R639 vdd.n220 vdd.n217 16.0005
R640 vdd.n217 vdd.n214 16.0005
R641 vdd.n214 vdd.n211 16.0005
R642 vdd.n211 vdd.n208 16.0005
R643 vdd.n208 vdd.n205 16.0005
R644 vdd.n205 vdd.n202 16.0005
R645 vdd.n202 vdd.n199 16.0005
R646 vdd.n199 vdd.n196 16.0005
R647 vdd.n193 vdd.n333 189.355
R648 vdd.n335 vdd.n334 2.68753
R649 vdd.n336 vdd.n335 0.15675
R650 vdd.n337 vdd.n336 0.15675
R651 vdd.n338 vdd.n337 0.15675
R652 vdd.n339 vdd.n338 0.15675
R653 vdd.n340 vdd.n339 0.15675
R654 vdd.n341 vdd.n340 0.15675
R655 vdd.n342 vdd.n341 0.15675
R656 vdd.n343 vdd.n342 0.15675
R657 vdd.n380 vdd.n343 0.09425
R658 vdd.n344 vdd.n380 0.063
R659 vdd.n345 vdd.n344 0.15675
R660 vdd.n346 vdd.n345 0.15675
R661 vdd.n347 vdd.n346 0.15675
R662 vdd.n348 vdd.n347 0.15675
R663 vdd.n349 vdd.n348 0.15675
R664 vdd.n350 vdd.n349 0.15675
R665 vdd.n351 vdd.n350 0.15675
R666 vdd.n352 vdd.n351 0.15675
R667 vdd.n353 vdd.n352 0.15675
R668 vdd.n354 vdd.n353 0.15675
R669 vdd.n355 vdd.n354 0.15675
R670 vdd.n356 vdd.n355 0.15675
R671 vdd.n357 vdd.n356 0.15675
R672 vdd.n358 vdd.n357 0.15675
R673 vdd.n359 vdd.n358 0.15675
R674 vdd.n360 vdd.n359 0.15675
R675 vdd.n361 vdd.n360 0.15675
R676 vdd.n362 vdd.n361 0.15675
R677 vdd.n363 vdd.n362 0.15675
R678 vdd.n364 vdd.n363 0.15675
R679 vdd.n365 vdd.n364 0.15675
R680 vdd.n366 vdd.n365 0.15675
R681 vdd.n367 vdd.n366 0.15675
R682 vdd.n368 vdd.n367 0.15675
R683 vdd.n369 vdd.n368 0.15675
R684 vdd.n382 vdd.n369 0.063
R685 vdd.n370 vdd.n382 0.09425
R686 vdd.n371 vdd.n370 0.15675
R687 vdd.n372 vdd.n371 0.15675
R688 vdd.n373 vdd.n372 0.15675
R689 vdd.n374 vdd.n373 0.15675
R690 vdd.n375 vdd.n374 0.15675
R691 vdd.n376 vdd.n375 0.15675
R692 vdd.n377 vdd.n376 0.15675
R693 vdd.n378 vdd.n377 0.15675
R694 vdd.n333 vdd.n378 2.68753
R695 vdd.n382 vdd.n381 41.2469
R696 vdd.n381 vdd.t7 13.1318
R697 vdd.n381 vdd.t15 13.1318
R698 vdd.n380 vdd.n379 41.2469
R699 vdd.n379 vdd.t3 13.1318
R700 vdd.n379 vdd.t1 13.1318
R701 vdd.n332 vdd.n330 114.001
R702 vdd.n330 vdd.n327 114.001
R703 vdd.n327 vdd.n324 114.001
R704 vdd.n324 vdd.n321 114.001
R705 vdd.n321 vdd.n318 114.001
R706 vdd.n318 vdd.n315 114.001
R707 vdd.n315 vdd.n312 114.001
R708 vdd.n312 vdd.n309 114.001
R709 vdd.n309 vdd.n306 114.001
R710 vdd.n306 vdd.n303 114.001
R711 vdd.n303 vdd.n300 114.001
R712 vdd.n300 vdd.n297 114.001
R713 vdd.n297 vdd.n294 114.001
R714 vdd.n294 vdd.n291 114.001
R715 vdd.n291 vdd.n288 114.001
R716 vdd.n288 vdd.n285 114.001
R717 vdd.n285 vdd.n282 114.001
R718 vdd.n282 vdd.n279 114.001
R719 vdd.n279 vdd.n276 114.001
R720 vdd.n276 vdd.n273 114.001
R721 vdd.n273 vdd.n270 114.001
R722 vdd.n270 vdd.n267 114.001
R723 vdd.n267 vdd.n264 114.001
R724 vdd.n264 vdd.n261 114.001
R725 vdd.n261 vdd.n258 114.001
R726 vdd.n258 vdd.n255 114.001
R727 vdd.n255 vdd.n252 114.001
R728 vdd.n252 vdd.n249 114.001
R729 vdd.n249 vdd.n246 114.001
R730 vdd.n246 vdd.n243 114.001
R731 vdd.n243 vdd.n240 114.001
R732 vdd.n240 vdd.n237 114.001
R733 vdd.n237 vdd.n234 114.001
R734 vdd.n234 vdd.n231 114.001
R735 vdd.n231 vdd.n228 114.001
R736 vdd.n228 vdd.n225 114.001
R737 vdd.n225 vdd.n222 114.001
R738 vdd.n222 vdd.n219 114.001
R739 vdd.n219 vdd.n216 114.001
R740 vdd.n216 vdd.n213 114.001
R741 vdd.n213 vdd.n210 114.001
R742 vdd.n210 vdd.n207 114.001
R743 vdd.n207 vdd.n204 114.001
R744 vdd.n204 vdd.n201 114.001
R745 vdd.n201 vdd.n198 114.001
R746 vdd.n198 vdd.n195 114.001
R747 vdd.n195 vdd.n193 114.001
R748 vdd.n25 vdd.n24 41.2469
R749 vdd.n24 vdd.t9 13.1318
R750 vdd.n24 vdd.t13 13.1318
R751 w_50_n4800.t10 w_50_n4800.n309 22.3509
R752 w_50_n4800.n1 w_50_n4800.n2 4.28224
R753 w_50_n4800.n4 w_50_n4800.n3 9.3005
R754 w_50_n4800.n6 w_50_n4800.n5 9.3005
R755 w_50_n4800.n8 w_50_n4800.n7 9.3005
R756 w_50_n4800.n10 w_50_n4800.n9 9.3005
R757 w_50_n4800.n13 w_50_n4800.n11 9.3005
R758 w_50_n4800.n15 w_50_n4800.n14 9.3005
R759 w_50_n4800.n17 w_50_n4800.n16 9.3005
R760 w_50_n4800.n19 w_50_n4800.n18 9.3005
R761 w_50_n4800.n21 w_50_n4800.n20 9.3005
R762 w_50_n4800.n23 w_50_n4800.n22 9.3005
R763 w_50_n4800.n25 w_50_n4800.n24 9.3005
R764 w_50_n4800.n27 w_50_n4800.n26 9.3005
R765 w_50_n4800.n29 w_50_n4800.n28 9.3005
R766 w_50_n4800.n31 w_50_n4800.n30 9.3005
R767 w_50_n4800.n33 w_50_n4800.n32 9.3005
R768 w_50_n4800.n35 w_50_n4800.n34 9.3005
R769 w_50_n4800.n37 w_50_n4800.n36 9.3005
R770 w_50_n4800.n39 w_50_n4800.n38 9.3005
R771 w_50_n4800.n41 w_50_n4800.n40 9.3005
R772 w_50_n4800.n43 w_50_n4800.n42 9.3005
R773 w_50_n4800.n45 w_50_n4800.n44 9.3005
R774 w_50_n4800.n47 w_50_n4800.n46 9.3005
R775 w_50_n4800.n49 w_50_n4800.n48 9.3005
R776 w_50_n4800.n51 w_50_n4800.n50 9.3005
R777 w_50_n4800.n53 w_50_n4800.n52 9.3005
R778 w_50_n4800.n55 w_50_n4800.n54 9.3005
R779 w_50_n4800.n57 w_50_n4800.n56 9.3005
R780 w_50_n4800.n59 w_50_n4800.n58 9.3005
R781 w_50_n4800.n61 w_50_n4800.n60 9.3005
R782 w_50_n4800.n63 w_50_n4800.n62 9.3005
R783 w_50_n4800.n65 w_50_n4800.n64 9.3005
R784 w_50_n4800.n67 w_50_n4800.n66 9.3005
R785 w_50_n4800.n69 w_50_n4800.n68 9.3005
R786 w_50_n4800.n71 w_50_n4800.n70 9.3005
R787 w_50_n4800.n73 w_50_n4800.n72 9.3005
R788 w_50_n4800.n75 w_50_n4800.n74 9.3005
R789 w_50_n4800.n77 w_50_n4800.n76 9.3005
R790 w_50_n4800.n79 w_50_n4800.n78 9.3005
R791 w_50_n4800.n81 w_50_n4800.n80 9.3005
R792 w_50_n4800.n83 w_50_n4800.n82 9.3005
R793 w_50_n4800.n86 w_50_n4800.n84 9.3005
R794 w_50_n4800.n88 w_50_n4800.n87 9.3005
R795 w_50_n4800.n90 w_50_n4800.n89 9.3005
R796 w_50_n4800.n92 w_50_n4800.n91 9.3005
R797 w_50_n4800.n94 w_50_n4800.n93 9.3005
R798 w_50_n4800.n0 w_50_n4800.n95 4.28224
R799 w_50_n4800.n4 w_50_n4800.n1 2.68753
R800 w_50_n4800.n6 w_50_n4800.n4 0.15675
R801 w_50_n4800.n8 w_50_n4800.n6 0.15675
R802 w_50_n4800.n10 w_50_n4800.n8 0.15675
R803 w_50_n4800.n13 w_50_n4800.n10 0.15675
R804 w_50_n4800.n15 w_50_n4800.n13 0.15675
R805 w_50_n4800.n17 w_50_n4800.n15 0.15675
R806 w_50_n4800.n19 w_50_n4800.n17 0.15675
R807 w_50_n4800.n21 w_50_n4800.n19 0.15675
R808 w_50_n4800.n23 w_50_n4800.n21 0.15675
R809 w_50_n4800.n25 w_50_n4800.n23 0.15675
R810 w_50_n4800.n27 w_50_n4800.n25 0.15675
R811 w_50_n4800.n29 w_50_n4800.n27 0.15675
R812 w_50_n4800.n31 w_50_n4800.n29 0.15675
R813 w_50_n4800.n33 w_50_n4800.n31 0.15675
R814 w_50_n4800.n35 w_50_n4800.n33 0.15675
R815 w_50_n4800.n37 w_50_n4800.n35 0.15675
R816 w_50_n4800.n308 w_50_n4800.n37 0.063
R817 w_50_n4800.n39 w_50_n4800.n308 0.09425
R818 w_50_n4800.n41 w_50_n4800.n39 0.15675
R819 w_50_n4800.n43 w_50_n4800.n41 0.15675
R820 w_50_n4800.n45 w_50_n4800.n43 0.15675
R821 w_50_n4800.n47 w_50_n4800.n45 0.15675
R822 w_50_n4800.n49 w_50_n4800.n47 0.15675
R823 w_50_n4800.n51 w_50_n4800.n49 0.15675
R824 w_50_n4800.n53 w_50_n4800.n51 0.15675
R825 w_50_n4800.n55 w_50_n4800.n53 0.15675
R826 w_50_n4800.n57 w_50_n4800.n55 0.15675
R827 w_50_n4800.n59 w_50_n4800.n57 0.15675
R828 w_50_n4800.n61 w_50_n4800.n59 0.15675
R829 w_50_n4800.n309 w_50_n4800.n61 0.1255
R830 w_50_n4800.n309 w_50_n4800.n63 0.03175
R831 w_50_n4800.n63 w_50_n4800.n65 0.15675
R832 w_50_n4800.n65 w_50_n4800.n67 0.15675
R833 w_50_n4800.n67 w_50_n4800.n69 0.15675
R834 w_50_n4800.n69 w_50_n4800.n71 0.15675
R835 w_50_n4800.n71 w_50_n4800.n73 0.15675
R836 w_50_n4800.n73 w_50_n4800.n75 0.15675
R837 w_50_n4800.n75 w_50_n4800.n77 0.15675
R838 w_50_n4800.n77 w_50_n4800.n79 0.15675
R839 w_50_n4800.n79 w_50_n4800.n81 0.15675
R840 w_50_n4800.n81 w_50_n4800.n83 0.15675
R841 w_50_n4800.n83 w_50_n4800.n86 0.15675
R842 w_50_n4800.n86 w_50_n4800.n88 0.15675
R843 w_50_n4800.n88 w_50_n4800.n90 0.15675
R844 w_50_n4800.n90 w_50_n4800.n92 0.15675
R845 w_50_n4800.n92 w_50_n4800.n94 0.15675
R846 w_50_n4800.n94 w_50_n4800.n0 2.68753
R847 w_50_n4800.n308 w_50_n4800.n307 14.5144
R848 w_50_n4800.n307 w_50_n4800.t6 7.838
R849 w_50_n4800.n307 w_50_n4800.t8 7.838
R850 w_50_n4800.n96 w_50_n4800.n244 585
R851 w_50_n4800.n0 w_50_n4800.n96 589.355
R852 w_50_n4800.n98 w_50_n4800.n97 585
R853 w_50_n4800.n95 w_50_n4800.n98 585
R854 w_50_n4800.n100 w_50_n4800.n99 585
R855 w_50_n4800.n93 w_50_n4800.n100 585
R856 w_50_n4800.n102 w_50_n4800.n101 585
R857 w_50_n4800.n91 w_50_n4800.n102 585
R858 w_50_n4800.n104 w_50_n4800.n103 585
R859 w_50_n4800.n89 w_50_n4800.n104 585
R860 w_50_n4800.n106 w_50_n4800.n105 585
R861 w_50_n4800.n87 w_50_n4800.n106 585
R862 w_50_n4800.n108 w_50_n4800.n107 585
R863 w_50_n4800.n84 w_50_n4800.n108 585
R864 w_50_n4800.n110 w_50_n4800.n109 585
R865 w_50_n4800.n82 w_50_n4800.n110 585
R866 w_50_n4800.n112 w_50_n4800.n111 585
R867 w_50_n4800.n80 w_50_n4800.n112 585
R868 w_50_n4800.n114 w_50_n4800.n113 585
R869 w_50_n4800.n78 w_50_n4800.n114 585
R870 w_50_n4800.n116 w_50_n4800.n115 585
R871 w_50_n4800.n76 w_50_n4800.n116 585
R872 w_50_n4800.n118 w_50_n4800.n117 585
R873 w_50_n4800.n74 w_50_n4800.n118 585
R874 w_50_n4800.n120 w_50_n4800.n119 585
R875 w_50_n4800.n72 w_50_n4800.n120 585
R876 w_50_n4800.n122 w_50_n4800.n121 585
R877 w_50_n4800.n70 w_50_n4800.n122 585
R878 w_50_n4800.n124 w_50_n4800.n123 585
R879 w_50_n4800.n68 w_50_n4800.n124 585
R880 w_50_n4800.n126 w_50_n4800.n125 585
R881 w_50_n4800.n66 w_50_n4800.n126 585
R882 w_50_n4800.n128 w_50_n4800.n127 585
R883 w_50_n4800.n64 w_50_n4800.n128 585
R884 w_50_n4800.n130 w_50_n4800.n129 585
R885 w_50_n4800.n62 w_50_n4800.n130 585
R886 w_50_n4800.n132 w_50_n4800.n131 585
R887 w_50_n4800.n60 w_50_n4800.n132 585
R888 w_50_n4800.n134 w_50_n4800.n133 585
R889 w_50_n4800.n58 w_50_n4800.n134 585
R890 w_50_n4800.n136 w_50_n4800.n135 585
R891 w_50_n4800.n56 w_50_n4800.n136 585
R892 w_50_n4800.n138 w_50_n4800.n137 585
R893 w_50_n4800.n54 w_50_n4800.n138 585
R894 w_50_n4800.n140 w_50_n4800.n139 585
R895 w_50_n4800.n52 w_50_n4800.n140 585
R896 w_50_n4800.n142 w_50_n4800.n141 585
R897 w_50_n4800.n50 w_50_n4800.n142 585
R898 w_50_n4800.n144 w_50_n4800.n143 585
R899 w_50_n4800.n48 w_50_n4800.n144 585
R900 w_50_n4800.n146 w_50_n4800.n145 585
R901 w_50_n4800.n46 w_50_n4800.n146 585
R902 w_50_n4800.n148 w_50_n4800.n147 585
R903 w_50_n4800.n44 w_50_n4800.n148 585
R904 w_50_n4800.n150 w_50_n4800.n149 585
R905 w_50_n4800.n42 w_50_n4800.n150 585
R906 w_50_n4800.n152 w_50_n4800.n151 585
R907 w_50_n4800.n40 w_50_n4800.n152 585
R908 w_50_n4800.n154 w_50_n4800.n153 585
R909 w_50_n4800.n38 w_50_n4800.n154 585
R910 w_50_n4800.n156 w_50_n4800.n155 585
R911 w_50_n4800.n36 w_50_n4800.n156 585
R912 w_50_n4800.n158 w_50_n4800.n157 585
R913 w_50_n4800.n34 w_50_n4800.n158 585
R914 w_50_n4800.n159 w_50_n4800.t15 585
R915 w_50_n4800.n32 w_50_n4800.n159 585
R916 w_50_n4800.n161 w_50_n4800.n160 585
R917 w_50_n4800.n30 w_50_n4800.n161 585
R918 w_50_n4800.n163 w_50_n4800.n162 585
R919 w_50_n4800.n28 w_50_n4800.n163 585
R920 w_50_n4800.n165 w_50_n4800.n164 585
R921 w_50_n4800.n26 w_50_n4800.n165 585
R922 w_50_n4800.n167 w_50_n4800.n166 585
R923 w_50_n4800.n24 w_50_n4800.n167 585
R924 w_50_n4800.n169 w_50_n4800.n168 585
R925 w_50_n4800.n22 w_50_n4800.n169 585
R926 w_50_n4800.n171 w_50_n4800.n170 585
R927 w_50_n4800.n20 w_50_n4800.n171 585
R928 w_50_n4800.n173 w_50_n4800.n172 585
R929 w_50_n4800.n18 w_50_n4800.n173 585
R930 w_50_n4800.n16 w_50_n4800.n174 585
R931 w_50_n4800.n176 w_50_n4800.n175 585
R932 w_50_n4800.n14 w_50_n4800.n176 585
R933 w_50_n4800.n178 w_50_n4800.n177 585
R934 w_50_n4800.n11 w_50_n4800.n178 585
R935 w_50_n4800.n180 w_50_n4800.n179 585
R936 w_50_n4800.n9 w_50_n4800.n180 585
R937 w_50_n4800.n182 w_50_n4800.n181 585
R938 w_50_n4800.n7 w_50_n4800.n182 585
R939 w_50_n4800.n184 w_50_n4800.n183 585
R940 w_50_n4800.n5 w_50_n4800.n184 585
R941 w_50_n4800.n186 w_50_n4800.n185 585
R942 w_50_n4800.n3 w_50_n4800.n186 585
R943 w_50_n4800.n188 w_50_n4800.n187 585
R944 w_50_n4800.n2 w_50_n4800.n188 585
R945 w_50_n4800.n306 w_50_n4800.n305 585
R946 w_50_n4800.n1 w_50_n4800.n306 589.355
R947 w_50_n4800.n2 w_50_n4800.n3 16.0005
R948 w_50_n4800.n3 w_50_n4800.n5 16.0005
R949 w_50_n4800.n5 w_50_n4800.n7 16.0005
R950 w_50_n4800.n7 w_50_n4800.n9 16.0005
R951 w_50_n4800.n9 w_50_n4800.n11 16.0005
R952 w_50_n4800.n11 w_50_n4800.n14 16.0005
R953 w_50_n4800.n14 w_50_n4800.n16 16.0005
R954 w_50_n4800.n16 w_50_n4800.n18 16.0005
R955 w_50_n4800.n18 w_50_n4800.n20 16.0005
R956 w_50_n4800.n20 w_50_n4800.n22 16.0005
R957 w_50_n4800.n22 w_50_n4800.n24 16.0005
R958 w_50_n4800.n24 w_50_n4800.n26 16.0005
R959 w_50_n4800.n26 w_50_n4800.n28 16.0005
R960 w_50_n4800.n28 w_50_n4800.n30 16.0005
R961 w_50_n4800.n30 w_50_n4800.n32 16.0005
R962 w_50_n4800.n32 w_50_n4800.n34 16.0005
R963 w_50_n4800.n34 w_50_n4800.n36 16.0005
R964 w_50_n4800.n36 w_50_n4800.n38 16.0005
R965 w_50_n4800.n38 w_50_n4800.n40 16.0005
R966 w_50_n4800.n40 w_50_n4800.n42 16.0005
R967 w_50_n4800.n42 w_50_n4800.n44 16.0005
R968 w_50_n4800.n44 w_50_n4800.n46 16.0005
R969 w_50_n4800.n46 w_50_n4800.n48 16.0005
R970 w_50_n4800.n48 w_50_n4800.n50 16.0005
R971 w_50_n4800.n50 w_50_n4800.n52 16.0005
R972 w_50_n4800.n52 w_50_n4800.n54 16.0005
R973 w_50_n4800.n54 w_50_n4800.n56 16.0005
R974 w_50_n4800.n56 w_50_n4800.n58 16.0005
R975 w_50_n4800.n58 w_50_n4800.n60 16.0005
R976 w_50_n4800.n60 w_50_n4800.n62 16.0005
R977 w_50_n4800.n62 w_50_n4800.n64 16.0005
R978 w_50_n4800.n64 w_50_n4800.n66 16.0005
R979 w_50_n4800.n66 w_50_n4800.n68 16.0005
R980 w_50_n4800.n68 w_50_n4800.n70 16.0005
R981 w_50_n4800.n70 w_50_n4800.n72 16.0005
R982 w_50_n4800.n72 w_50_n4800.n74 16.0005
R983 w_50_n4800.n74 w_50_n4800.n76 16.0005
R984 w_50_n4800.n76 w_50_n4800.n78 16.0005
R985 w_50_n4800.n78 w_50_n4800.n80 16.0005
R986 w_50_n4800.n80 w_50_n4800.n82 16.0005
R987 w_50_n4800.n82 w_50_n4800.n84 16.0005
R988 w_50_n4800.n84 w_50_n4800.n87 16.0005
R989 w_50_n4800.n87 w_50_n4800.n89 16.0005
R990 w_50_n4800.n89 w_50_n4800.n91 16.0005
R991 w_50_n4800.n91 w_50_n4800.n93 16.0005
R992 w_50_n4800.n93 w_50_n4800.n95 16.0005
R993 w_50_n4800.n306 w_50_n4800.n188 191
R994 w_50_n4800.n188 w_50_n4800.n186 191
R995 w_50_n4800.n186 w_50_n4800.n184 191
R996 w_50_n4800.n184 w_50_n4800.n182 191
R997 w_50_n4800.n182 w_50_n4800.n180 191
R998 w_50_n4800.n180 w_50_n4800.n178 191
R999 w_50_n4800.n178 w_50_n4800.n176 191
R1000 w_50_n4800.n176 w_50_n4800.n174 191
R1001 w_50_n4800.n174 w_50_n4800.n173 191
R1002 w_50_n4800.n173 w_50_n4800.n171 191
R1003 w_50_n4800.n171 w_50_n4800.n169 191
R1004 w_50_n4800.n169 w_50_n4800.n167 191
R1005 w_50_n4800.n167 w_50_n4800.n165 191
R1006 w_50_n4800.n165 w_50_n4800.n163 191
R1007 w_50_n4800.n163 w_50_n4800.n161 191
R1008 w_50_n4800.n161 w_50_n4800.n159 191
R1009 w_50_n4800.n159 w_50_n4800.n158 191
R1010 w_50_n4800.n158 w_50_n4800.n156 191
R1011 w_50_n4800.n156 w_50_n4800.n154 191
R1012 w_50_n4800.n154 w_50_n4800.n152 191
R1013 w_50_n4800.n152 w_50_n4800.n150 191
R1014 w_50_n4800.n150 w_50_n4800.n148 191
R1015 w_50_n4800.n148 w_50_n4800.n146 191
R1016 w_50_n4800.n146 w_50_n4800.n144 191
R1017 w_50_n4800.n144 w_50_n4800.n142 191
R1018 w_50_n4800.n142 w_50_n4800.n140 191
R1019 w_50_n4800.n140 w_50_n4800.n138 191
R1020 w_50_n4800.n138 w_50_n4800.n136 191
R1021 w_50_n4800.n136 w_50_n4800.n134 191
R1022 w_50_n4800.n134 w_50_n4800.n132 191
R1023 w_50_n4800.n132 w_50_n4800.n130 191
R1024 w_50_n4800.n130 w_50_n4800.n128 191
R1025 w_50_n4800.n128 w_50_n4800.n126 191
R1026 w_50_n4800.n126 w_50_n4800.n124 191
R1027 w_50_n4800.n124 w_50_n4800.n122 191
R1028 w_50_n4800.n122 w_50_n4800.n120 191
R1029 w_50_n4800.n120 w_50_n4800.n118 191
R1030 w_50_n4800.n118 w_50_n4800.n116 191
R1031 w_50_n4800.n116 w_50_n4800.n114 191
R1032 w_50_n4800.n114 w_50_n4800.n112 191
R1033 w_50_n4800.n112 w_50_n4800.n110 191
R1034 w_50_n4800.n110 w_50_n4800.n108 191
R1035 w_50_n4800.n108 w_50_n4800.n106 191
R1036 w_50_n4800.n106 w_50_n4800.n104 191
R1037 w_50_n4800.n104 w_50_n4800.n102 191
R1038 w_50_n4800.n102 w_50_n4800.n100 191
R1039 w_50_n4800.n100 w_50_n4800.n98 191
R1040 w_50_n4800.n98 w_50_n4800.n96 191
R1041 w_50_n4800.n189 w_50_n4800.n190 54.8648
R1042 w_50_n4800.n190 w_50_n4800.n191 585
R1043 w_50_n4800.n192 w_50_n4800.n193 585
R1044 w_50_n4800.n193 w_50_n4800.n194 585
R1045 w_50_n4800.n195 w_50_n4800.n196 585
R1046 w_50_n4800.n196 w_50_n4800.n197 585
R1047 w_50_n4800.n198 w_50_n4800.n199 585
R1048 w_50_n4800.n199 w_50_n4800.n200 585
R1049 w_50_n4800.n201 w_50_n4800.n202 585
R1050 w_50_n4800.n208 w_50_n4800.n209 585
R1051 w_50_n4800.n210 w_50_n4800.n211 585
R1052 w_50_n4800.n211 w_50_n4800.n212 585
R1053 w_50_n4800.n213 w_50_n4800.n214 585
R1054 w_50_n4800.n214 w_50_n4800.n215 585
R1055 w_50_n4800.n207 w_50_n4800.n216 195
R1056 w_50_n4800.n219 w_50_n4800.n220 585
R1057 w_50_n4800.n221 w_50_n4800.n222 585
R1058 w_50_n4800.n222 w_50_n4800.n223 585
R1059 w_50_n4800.n224 w_50_n4800.n225 585
R1060 w_50_n4800.n225 w_50_n4800.n226 585
R1061 w_50_n4800.t0 w_50_n4800.n227 585
R1062 w_50_n4800.n231 w_50_n4800.n232 585
R1063 w_50_n4800.n233 w_50_n4800.n234 585
R1064 w_50_n4800.n234 w_50_n4800.n235 585
R1065 w_50_n4800.n236 w_50_n4800.n237 585
R1066 w_50_n4800.n237 w_50_n4800.n238 585
R1067 w_50_n4800.n239 w_50_n4800.n240 585
R1068 w_50_n4800.n243 w_50_n4800.n245 24.1839
R1069 w_50_n4800.n245 w_50_n4800.n246 585
R1070 w_50_n4800.n247 w_50_n4800.n248 585
R1071 w_50_n4800.n248 w_50_n4800.n249 585
R1072 w_50_n4800.n250 w_50_n4800.n251 585
R1073 w_50_n4800.n251 w_50_n4800.n252 585
R1074 w_50_n4800.n253 w_50_n4800.n254 585
R1075 w_50_n4800.n254 w_50_n4800.n255 585
R1076 w_50_n4800.n256 w_50_n4800.n257 585
R1077 w_50_n4800.n257 w_50_n4800.n258 585
R1078 w_50_n4800.n259 w_50_n4800.n260 585
R1079 w_50_n4800.n260 w_50_n4800.n261 585
R1080 w_50_n4800.n262 w_50_n4800.n263 585
R1081 w_50_n4800.n263 w_50_n4800.n303 585
R1082 w_50_n4800.n264 w_50_n4800.n265 585
R1083 w_50_n4800.n265 w_50_n4800.n266 585
R1084 w_50_n4800.n267 w_50_n4800.n268 585
R1085 w_50_n4800.n268 w_50_n4800.n269 585
R1086 w_50_n4800.t21 w_50_n4800.n270 585
R1087 w_50_n4800.n270 w_50_n4800.n271 585
R1088 w_50_n4800.n272 w_50_n4800.n273 585
R1089 w_50_n4800.n273 w_50_n4800.n274 585
R1090 w_50_n4800.n275 w_50_n4800.n276 585
R1091 w_50_n4800.n276 w_50_n4800.n277 585
R1092 w_50_n4800.n278 w_50_n4800.n279 585
R1093 w_50_n4800.n279 w_50_n4800.n280 585
R1094 w_50_n4800.n281 w_50_n4800.n282 585
R1095 w_50_n4800.n282 w_50_n4800.n283 585
R1096 w_50_n4800.n284 w_50_n4800.n285 585
R1097 w_50_n4800.n286 w_50_n4800.n287 195
R1098 w_50_n4800.n287 w_50_n4800.n288 195
R1099 w_50_n4800.n305 w_50_n4800.n189 298.022
R1100 w_50_n4800.n305 w_50_n4800.n192 70.0005
R1101 w_50_n4800.n187 w_50_n4800.n192 13.3338
R1102 w_50_n4800.n187 w_50_n4800.t0 33.3338
R1103 w_50_n4800.t0 w_50_n4800.n195 38.3338
R1104 w_50_n4800.n185 w_50_n4800.n195 11.6672
R1105 w_50_n4800.n185 w_50_n4800.n224 35.0005
R1106 w_50_n4800.n224 w_50_n4800.n198 38.3338
R1107 w_50_n4800.t1 w_50_n4800.n198 1.66717
R1108 w_50_n4800.n183 w_50_n4800.t1 8.33383
R1109 w_50_n4800.n183 w_50_n4800.n221 36.6672
R1110 w_50_n4800.n221 w_50_n4800.n201 38.3338
R1111 w_50_n4800.n181 w_50_n4800.n201 8.33383
R1112 w_50_n4800.n181 w_50_n4800.n219 38.3338
R1113 w_50_n4800.n219 w_50_n4800.t13 11.6672
R1114 w_50_n4800.n179 w_50_n4800.t13 33.3338
R1115 w_50_n4800.n179 w_50_n4800.n177 83.3338
R1116 w_50_n4800.n177 w_50_n4800.n175 83.3338
R1117 w_50_n4800.n175 w_50_n4800.n230 81.7939
R1118 w_50_n4800.n174 w_50_n4800.n230 586.088
R1119 w_50_n4800.n230 w_50_n4800.n172 79.6372
R1120 w_50_n4800.n172 w_50_n4800.t3 8.33383
R1121 w_50_n4800.t3 w_50_n4800.n170 75.0005
R1122 w_50_n4800.n170 w_50_n4800.n168 83.3338
R1123 w_50_n4800.n168 w_50_n4800.n166 83.3338
R1124 w_50_n4800.n166 w_50_n4800.n239 58.3338
R1125 w_50_n4800.t14 w_50_n4800.n239 8.33383
R1126 w_50_n4800.n164 w_50_n4800.t14 16.6672
R1127 w_50_n4800.n164 w_50_n4800.n236 60.0005
R1128 w_50_n4800.n162 w_50_n4800.n236 23.3338
R1129 w_50_n4800.n162 w_50_n4800.n233 61.6672
R1130 w_50_n4800.n160 w_50_n4800.n233 21.6672
R1131 w_50_n4800.n160 w_50_n4800.t5 25.0005
R1132 w_50_n4800.t5 w_50_n4800.n231 38.3338
R1133 w_50_n4800.t15 w_50_n4800.n231 20.0005
R1134 w_50_n4800.t15 w_50_n4800.n157 83.3338
R1135 w_50_n4800.n157 w_50_n4800.n155 83.3338
R1136 w_50_n4800.n155 w_50_n4800.n153 83.3338
R1137 w_50_n4800.n153 w_50_n4800.n151 83.3338
R1138 w_50_n4800.n151 w_50_n4800.n149 83.3338
R1139 w_50_n4800.n149 w_50_n4800.t7 41.6672
R1140 w_50_n4800.n147 w_50_n4800.t7 41.6672
R1141 w_50_n4800.n147 w_50_n4800.n145 83.3338
R1142 w_50_n4800.n145 w_50_n4800.n143 83.3338
R1143 w_50_n4800.n143 w_50_n4800.n208 8.33383
R1144 w_50_n4800.n208 w_50_n4800.t11 8.33383
R1145 w_50_n4800.t11 w_50_n4800.n141 66.6672
R1146 w_50_n4800.n141 w_50_n4800.n210 10.0005
R1147 w_50_n4800.n210 w_50_n4800.n139 73.3338
R1148 w_50_n4800.n139 w_50_n4800.n213 11.6672
R1149 w_50_n4800.n213 w_50_n4800.n137 71.6672
R1150 w_50_n4800.n137 w_50_n4800.n207 29.1672
R1151 w_50_n4800.n207 w_50_n4800.t12 4.16717
R1152 w_50_n4800.t12 w_50_n4800.t9 25.0005
R1153 w_50_n4800.n135 w_50_n4800.t9 25.0005
R1154 w_50_n4800.n135 w_50_n4800.n133 83.3338
R1155 w_50_n4800.n133 w_50_n4800.n131 83.3338
R1156 w_50_n4800.n131 w_50_n4800.n284 41.6672
R1157 w_50_n4800.n129 w_50_n4800.n284 41.6672
R1158 w_50_n4800.n129 w_50_n4800.n281 43.3338
R1159 w_50_n4800.n127 w_50_n4800.n281 40.0005
R1160 w_50_n4800.n127 w_50_n4800.n278 45.0005
R1161 w_50_n4800.n125 w_50_n4800.n278 38.3338
R1162 w_50_n4800.n125 w_50_n4800.n275 46.6672
R1163 w_50_n4800.n123 w_50_n4800.n275 36.6672
R1164 w_50_n4800.n123 w_50_n4800.n272 48.3338
R1165 w_50_n4800.n121 w_50_n4800.n272 35.0005
R1166 w_50_n4800.n121 w_50_n4800.t21 50.0005
R1167 w_50_n4800.n119 w_50_n4800.t21 33.3338
R1168 w_50_n4800.n119 w_50_n4800.n267 51.6672
R1169 w_50_n4800.n117 w_50_n4800.n267 31.6672
R1170 w_50_n4800.n117 w_50_n4800.n264 53.3338
R1171 w_50_n4800.n115 w_50_n4800.n264 30.0005
R1172 w_50_n4800.n115 w_50_n4800.n262 55.0005
R1173 w_50_n4800.t16 w_50_n4800.n262 11.6672
R1174 w_50_n4800.t17 w_50_n4800.t16 8.33383
R1175 w_50_n4800.n113 w_50_n4800.t17 8.33383
R1176 w_50_n4800.n113 w_50_n4800.n111 83.3338
R1177 w_50_n4800.n111 w_50_n4800.n109 83.3338
R1178 w_50_n4800.n109 w_50_n4800.n286 12.5005
R1179 w_50_n4800.n286 w_50_n4800.n107 70.8338
R1180 w_50_n4800.n107 w_50_n4800.n259 75.0005
R1181 w_50_n4800.n105 w_50_n4800.n259 8.33383
R1182 w_50_n4800.n105 w_50_n4800.n256 76.6672
R1183 w_50_n4800.n103 w_50_n4800.n256 6.66717
R1184 w_50_n4800.n103 w_50_n4800.n253 78.3338
R1185 w_50_n4800.n101 w_50_n4800.n253 5.0005
R1186 w_50_n4800.n101 w_50_n4800.t19 8.33383
R1187 w_50_n4800.t19 w_50_n4800.n250 71.6672
R1188 w_50_n4800.n99 w_50_n4800.n250 3.33383
R1189 w_50_n4800.n99 w_50_n4800.n247 81.6672
R1190 w_50_n4800.n97 w_50_n4800.n247 1.66717
R1191 w_50_n4800.n97 w_50_n4800.n244 83.3338
R1192 w_50_n4800.n244 w_50_n4800.n243 299.401
R1193 w_50_n4800.n288 w_50_n4800.n289 3.1005
R1194 w_50_n4800.n261 w_50_n4800.n290 9.3005
R1195 w_50_n4800.n258 w_50_n4800.n291 9.3005
R1196 w_50_n4800.n292 w_50_n4800.n255 9.3005
R1197 w_50_n4800.n293 w_50_n4800.n252 9.3005
R1198 w_50_n4800.n294 w_50_n4800.n249 9.3005
R1199 w_50_n4800.n295 w_50_n4800.n246 1.60541
R1200 w_50_n4800.n288 w_50_n4800.n261 6.82726
R1201 w_50_n4800.n261 w_50_n4800.n258 3.88621
R1202 w_50_n4800.n258 w_50_n4800.n255 3.88621
R1203 w_50_n4800.n255 w_50_n4800.n252 3.88621
R1204 w_50_n4800.n252 w_50_n4800.n249 3.88621
R1205 w_50_n4800.n249 w_50_n4800.n246 3.88621
R1206 w_50_n4800.n290 w_50_n4800.n291 0.0384464
R1207 w_50_n4800.n291 w_50_n4800.n292 0.0384464
R1208 w_50_n4800.n292 w_50_n4800.n293 0.0384464
R1209 w_50_n4800.n293 w_50_n4800.n294 0.0384464
R1210 w_50_n4800.n294 w_50_n4800.n295 3.89458
R1211 w_50_n4800.n289 w_50_n4800.n290 0.0671676
R1212 w_50_n4800.n296 w_50_n4800.n283 1.78033
R1213 w_50_n4800.n297 w_50_n4800.n280 9.3005
R1214 w_50_n4800.n298 w_50_n4800.n277 9.3005
R1215 w_50_n4800.n299 w_50_n4800.n274 9.3005
R1216 w_50_n4800.n300 w_50_n4800.n271 9.3005
R1217 w_50_n4800.n301 w_50_n4800.n269 9.3005
R1218 w_50_n4800.n302 w_50_n4800.n266 9.3005
R1219 w_50_n4800.n303 w_50_n4800.n304 9.3005
R1220 w_50_n4800.n297 w_50_n4800.n296 3.8131
R1221 w_50_n4800.n298 w_50_n4800.n297 0.0435743
R1222 w_50_n4800.n299 w_50_n4800.n298 0.0435743
R1223 w_50_n4800.n300 w_50_n4800.n299 0.0435743
R1224 w_50_n4800.n301 w_50_n4800.n300 0.0435743
R1225 w_50_n4800.n302 w_50_n4800.n301 0.0435743
R1226 w_50_n4800.n304 w_50_n4800.n302 0.0435743
R1227 w_50_n4800.n289 w_50_n4800.n304 0.101261
R1228 w_50_n4800.n285 w_50_n4800.n296 586.788
R1229 w_50_n4800.n283 w_50_n4800.n280 4.41131
R1230 w_50_n4800.n280 w_50_n4800.n277 4.41131
R1231 w_50_n4800.n277 w_50_n4800.n274 4.41131
R1232 w_50_n4800.n274 w_50_n4800.n271 4.41131
R1233 w_50_n4800.n271 w_50_n4800.n269 4.41131
R1234 w_50_n4800.n269 w_50_n4800.n266 4.41131
R1235 w_50_n4800.n266 w_50_n4800.n303 4.41131
R1236 w_50_n4800.n288 w_50_n4800.n303 10.3184
R1237 w_50_n4800.n287 w_50_n4800.n260 94.7426
R1238 w_50_n4800.n260 w_50_n4800.n257 54.1172
R1239 w_50_n4800.n257 w_50_n4800.n254 54.1172
R1240 w_50_n4800.n254 w_50_n4800.n251 54.1172
R1241 w_50_n4800.n248 w_50_n4800.n251 54.1172
R1242 w_50_n4800.n245 w_50_n4800.n248 54.1172
R1243 w_50_n4800.n243 w_50_n4800.n295 614.309
R1244 w_50_n4800.n285 w_50_n4800.n282 60.8817
R1245 w_50_n4800.n282 w_50_n4800.n279 60.8817
R1246 w_50_n4800.n279 w_50_n4800.n276 60.8817
R1247 w_50_n4800.n276 w_50_n4800.n273 60.8817
R1248 w_50_n4800.n270 w_50_n4800.n273 60.8817
R1249 w_50_n4800.n268 w_50_n4800.n270 60.8817
R1250 w_50_n4800.n265 w_50_n4800.n268 60.8817
R1251 w_50_n4800.n263 w_50_n4800.n265 60.8817
R1252 w_50_n4800.n287 w_50_n4800.n263 142.227
R1253 w_50_n4800.n238 w_50_n4800.n242 3.91282
R1254 w_50_n4800.n235 w_50_n4800.n241 3.91282
R1255 w_50_n4800.n240 w_50_n4800.n242 588.968
R1256 w_50_n4800.n238 w_50_n4800.n235 13.6005
R1257 w_50_n4800.n232 w_50_n4800.n241 588.968
R1258 w_50_n4800.n242 w_50_n4800.n241 5.5607
R1259 w_50_n4800.n240 w_50_n4800.n237 162.351
R1260 w_50_n4800.n237 w_50_n4800.n234 162.351
R1261 w_50_n4800.n234 w_50_n4800.n232 162.351
R1262 w_50_n4800.n226 w_50_n4800.n229 4.16217
R1263 w_50_n4800.n223 w_50_n4800.n228 4.16217
R1264 w_50_n4800.n227 w_50_n4800.n229 589.229
R1265 w_50_n4800.n226 w_50_n4800.n223 15.1819
R1266 w_50_n4800.n228 w_50_n4800.n220 589.229
R1267 w_50_n4800.n229 w_50_n4800.n228 5.32922
R1268 w_50_n4800.n227 w_50_n4800.n225 177.109
R1269 w_50_n4800.n225 w_50_n4800.n222 177.109
R1270 w_50_n4800.n222 w_50_n4800.n220 177.109
R1271 w_50_n4800.n217 w_50_n4800.n212 2.06109
R1272 w_50_n4800.n218 w_50_n4800.n215 3.12255
R1273 w_50_n4800.n209 w_50_n4800.n217 587.072
R1274 w_50_n4800.n212 w_50_n4800.n215 5.30782
R1275 w_50_n4800.n216 w_50_n4800.n218 196.062
R1276 w_50_n4800.n218 w_50_n4800.n217 5.25082
R1277 w_50_n4800.n211 w_50_n4800.n209 72.1561
R1278 w_50_n4800.n214 w_50_n4800.n211 72.1561
R1279 w_50_n4800.n216 w_50_n4800.n214 85.5968
R1280 w_50_n4800.n191 w_50_n4800.n203 3.31674
R1281 w_50_n4800.n194 w_50_n4800.n204 9.3005
R1282 w_50_n4800.n205 w_50_n4800.n197 9.3005
R1283 w_50_n4800.n206 w_50_n4800.n200 3.31674
R1284 w_50_n4800.n191 w_50_n4800.n194 10.3624
R1285 w_50_n4800.n194 w_50_n4800.n197 10.3624
R1286 w_50_n4800.n197 w_50_n4800.n200 10.3624
R1287 w_50_n4800.n206 w_50_n4800.n202 588.352
R1288 w_50_n4800.n203 w_50_n4800.n204 3.11051
R1289 w_50_n4800.n204 w_50_n4800.n205 0.10169
R1290 w_50_n4800.n205 w_50_n4800.n206 3.11051
R1291 w_50_n4800.n203 w_50_n4800.n189 651.188
R1292 w_50_n4800.n190 w_50_n4800.n193 129.881
R1293 w_50_n4800.n193 w_50_n4800.n196 129.881
R1294 w_50_n4800.n196 w_50_n4800.n199 129.881
R1295 w_50_n4800.n199 w_50_n4800.n202 129.881
R1296 w_50_n4800.n86 w_50_n4800.n85 14.5144
R1297 w_50_n4800.n85 w_50_n4800.t18 7.838
R1298 w_50_n4800.n85 w_50_n4800.t20 7.838
R1299 w_50_n4800.n13 w_50_n4800.n12 14.5144
R1300 w_50_n4800.n12 w_50_n4800.t2 7.838
R1301 w_50_n4800.n12 w_50_n4800.t4 7.838
C0 nmir iout_n 0.47317f
C1 iout_p b1 0.01238f
C2 b0 a1 0.10027f
C3 nmir nsum 0.41833f
C4 nsum b0 0.3564f
C5 iout_p sgn 0.34329f
C6 vg4 vdd 6.66327f
C7 nsum iout_p 0.3224f
C8 b1 sgn 0.08928f
C9 sgnb sgn 0.07178f
C10 nsum b1 0.74703f
C11 nsum sgnb 0.21673f
C12 vg vcasc 2.82687f
C13 nsum sgn 0.35191f
C14 b0 b1 0.05219f
C15 nmir sgnb 0.40359f
C16 vg4 vg 2.95603f
C17 vg4 vcasc 2.28539f
C18 nsum a1 0.67474f
C19 nmir sgn 0.04192f
C20 a0 a1 0.06918f
C21 vg vdd 6.11178f
C22 vcasc vdd 7.71728f
C23 nsum a0 0.21854f
C24 iout_n 0 1.50281f
C25 nmir 0 5.45806f
C26 iout_p 0 0.79269f
C27 nsum 0 2.13764f
C28 sgnb 0 0.53247f
C29 sgn 0 0.51617f
C30 b1 0 0.92214f
C31 b0 0 0.51678f
C32 a1 0 1.05633f
C33 a0 0 0.56903f
C34 vg 0 0.99471f
C35 vg4 0 3.89988f
C36 vcasc 0 2.28142f
C37 vdd 0 97.3745f
C38 vdd.t5 0 0.06044f
C39 vdd.n0 0 0.12874f
C40 vdd.n1 0 0.01071f
C41 vdd.n4 0 0.01983f
C42 vdd.n24 0 0.12881f
C43 vdd.t9 0 0.06044f
C44 vdd.t13 0 0.06044f
C45 vdd.n25 0 0.1906f
C46 vdd.n93 0 0.01983f
C47 vdd.n95 0 0.03218f
C48 vdd.n96 0 1.18402f
C49 vdd.n97 0 0.01259f
C50 vdd.n98 0 0.21704f
C51 vdd.n100 0 0.15193f
C52 vdd.n102 0 0.21704f
C53 vdd.n104 0 0.19534f
C54 vdd.n106 0 0.21704f
C55 vdd.n108 0 0.21704f
C56 vdd.n110 0 0.10852f
C57 vdd.n112 0 0.21704f
C58 vdd.n114 0 0.15193f
C59 vdd.n116 0 0.21704f
C60 vdd.n118 0 0.21704f
C61 vdd.n120 0 0.21704f
C62 vdd.n122 0 0.15193f
C63 vdd.n124 0 0.21704f
C64 vdd.n126 0 0.10852f
C65 vdd.n128 0 0.21704f
C66 vdd.n130 0 0.21704f
C67 vdd.n132 0 0.19534f
C68 vdd.n134 0 0.21704f
C69 vdd.n136 0 0.15193f
C70 vdd.n138 0 0.21704f
C71 vdd.n140 0 0.21704f
C72 vdd.n142 0 0.21704f
C73 vdd.n144 0 0.21704f
C74 vdd.n146 0 0.21704f
C75 vdd.n148 0 0.21704f
C76 vdd.n150 0 0.21704f
C77 vdd.n152 0 0.19534f
C78 vdd.n154 0 0.19534f
C79 vdd.n156 0 0.21704f
C80 vdd.n158 0 0.21704f
C81 vdd.n160 0 0.21704f
C82 vdd.n162 0 0.15193f
C83 vdd.n164 0 0.21704f
C84 vdd.n166 0 0.19534f
C85 vdd.n168 0 0.21704f
C86 vdd.n170 0 0.21704f
C87 vdd.n172 0 0.21704f
C88 vdd.n174 0 0.10852f
C89 vdd.n176 0 0.21704f
C90 vdd.n178 0 0.15193f
C91 vdd.n180 0 0.21704f
C92 vdd.n182 0 0.21704f
C93 vdd.n184 0 0.15193f
C94 vdd.n186 0 0.21704f
C95 vdd.n188 0 0.10852f
C96 vdd.n190 0 0.2021f
C97 vdd.n192 0 1.59048f
C98 vdd.n194 0 0.21704f
C99 vdd.n197 0 0.15193f
C100 vdd.n200 0 0.21704f
C101 vdd.n203 0 0.21704f
C102 vdd.n206 0 0.21704f
C103 vdd.n209 0 0.19534f
C104 vdd.n212 0 0.19534f
C105 vdd.n215 0 0.21704f
C106 vdd.n218 0 0.21704f
C107 vdd.n221 0 0.21704f
C108 vdd.n224 0 0.21704f
C109 vdd.n227 0 0.15193f
C110 vdd.n230 0 0.21704f
C111 vdd.n233 0 0.19534f
C112 vdd.n236 0 0.21704f
C113 vdd.n239 0 0.21704f
C114 vdd.n242 0 0.10852f
C115 vdd.n245 0 0.21704f
C116 vdd.n248 0 0.15193f
C117 vdd.n251 0 0.21704f
C118 vdd.n254 0 0.21704f
C119 vdd.n257 0 0.21704f
C120 vdd.n260 0 0.21704f
C121 vdd.n263 0 0.21704f
C122 vdd.n266 0 0.21704f
C123 vdd.n269 0 0.15193f
C124 vdd.n272 0 0.21704f
C125 vdd.n275 0 0.10852f
C126 vdd.n278 0 0.21704f
C127 vdd.n281 0 0.21704f
C128 vdd.n284 0 0.19534f
C129 vdd.n287 0 0.21704f
C130 vdd.n290 0 0.15193f
C131 vdd.n293 0 0.21704f
C132 vdd.n296 0 0.21704f
C133 vdd.n299 0 0.21704f
C134 vdd.n302 0 0.21704f
C135 vdd.n305 0 0.19534f
C136 vdd.n308 0 0.19534f
C137 vdd.n311 0 0.21704f
C138 vdd.n314 0 0.21704f
C139 vdd.n317 0 0.21704f
C140 vdd.n320 0 0.15193f
C141 vdd.n323 0 0.21704f
C142 vdd.n326 0 0.19534f
C143 vdd.n329 0 0.21704f
C144 vdd.n332 0 0.04122f
C145 vdd.n335 0 0.0178f
C146 vdd.n378 0 0.0178f
C147 vdd.n379 0 0.12881f
C148 vdd.t3 0 0.06044f
C149 vdd.t1 0 0.06044f
C150 vdd.n380 0 0.18786f
C151 vdd.n381 0 0.12881f
C152 vdd.t7 0 0.06044f
C153 vdd.t15 0 0.06044f
C154 vdd.n382 0 0.18786f
C155 vdd.t16 0 0.08682f
C156 vdd.t8 0 0.08682f
C157 vdd.t12 0 0.13023f
C158 vdd.t17 0 0.13023f
C159 vdd.t18 0 0.13023f
C160 vdd.t10 0 0.08682f
C161 vdd.t4 0 0.08682f
C162 vdd.t19 0 0.13023f
C163 vdd.t20 0 0.08682f
C164 vdd.t2 0 0.13023f
C165 vdd.t0 0 0.13023f
C166 vdd.t21 0 0.13023f
C167 vdd.t22 0 0.08682f
C168 vdd.t6 0 0.08682f
C169 vdd.t14 0 0.13023f
C170 vdd.t23 0 0.13023f
C171 vdd.t11 0 0.06044f
C172 vg4.t1 0 0.25408f
C173 vg4.n0 0 0.70382f
C174 vg4.n1 0 0.84581f
C175 vg4.t4 0 1.77464f
C176 vg4.t5 0 1.77464f
C177 vg4.n2 0 1.42108f
C178 vg4.t0 0 1.77464f
C179 vg4.t3 0 1.77464f
C180 vg4.n3 0 1.04793f
C181 vg4.t2 0 0.25408f
C182 a_380_3740.t1 0 1.92787f
C183 a_380_3740.t0 0 2.17219f
C184 a_800_3740.t0 0 0.69803f
C185 a_800_3740.t1 0 0.69803f
C186 a_2040_3740.t0 0 0.68739f
C187 a_2040_3740.t1 0 0.68739f
C188 a_2460_3740.t1 0 2.02875f
C189 a_2460_3740.t0 0 2.3481f
C190 a_200_n4240.t0 0 2.27791f
C191 a_200_n4240.t1 0 3.57043f
C192 a_4620_3740.t0 0 0.70593f
C193 a_4620_3740.t1 0 0.70593f
C194 a_420_n4440.t0 0 0.40165f
C195 a_420_n4440.t5 0 0.55144f
C196 a_420_n4440.n0 0 0.26229f
C197 a_420_n4440.t8 0 0.0793f
C198 a_420_n4440.t6 0 0.0793f
C199 a_420_n4440.n1 0 0.17577f
C200 a_420_n4440.n2 0 0.26229f
C201 a_420_n4440.t2 0 0.0793f
C202 a_420_n4440.t4 0 0.0793f
C203 a_420_n4440.n3 0 0.17142f
C204 a_420_n4440.t1 0 0.55147f
C205 a_420_n4440.n4 0 0.30348f
C206 a_420_n4440.t9 0 0.55167f
C207 a_420_n4440.t7 0 0.55147f
C208 a_420_n4440.n5 0 0.15585f
C209 a_420_n4440.t3 0 0.55147f
C210 a_420_n4440.n6 0 0.15585f
C211 a_420_n4440.n7 0 1.0298f
C212 a_200_n2000.t0 0 0.80878f
C213 a_200_n2000.t1 0 1.03595f
C214 a_620_600.t0 0 0.69992f
C215 a_620_600.t1 0 0.69992f
C216 a_1860_600.t0 0 0.69388f
C217 a_1860_600.t1 0 0.69388f
C218 a_840_n2000.t1 0 1.5303f
C219 a_840_n2000.t0 0 1.85259f
C220 a_1340_n2000.t1 0 1.94992f
C221 a_1340_n2000.t0 0 2.35259f
C222 a_3200_600.t0 0 0.70082f
C223 a_3200_600.t1 0 0.70082f
C224 a_4440_600.t0 0 0.69296f
C225 a_4440_600.t1 0 0.69296f
C226 a_1980_n2000.t1 0 1.63834f
C227 a_1980_n2000.t0 0 1.89064f
C228 nsum.t0 0 0.15497f
C229 nsum.n0 0 0.40032f
C230 nsum.n1 0 0.44316f
C231 nsum.t4 0 0.15497f
C232 nsum.t5 0 0.15497f
C233 nsum.n2 0 0.89793f
C234 nsum.n3 0 0.44316f
C235 nsum.t1 0 0.15497f
C236 nsum.t2 0 0.15497f
C237 nsum.n4 0 1.33408f
C238 nsum.n5 0 0.45373f
C239 nsum.t7 0 0.15497f
C240 nsum.t6 0 0.15497f
C241 nsum.t3 0 0.15497f
C242 iout_p.t0 0 0.35932f
C243 nmir.t0 0 0.22264f
C244 nmir.t2 0 0.32465f
C245 nmir.t3 0 0.59348f
C246 nmir.t1 0 0.59296f
C247 nmir.n0 0 0.30695f
C248 iout_n.t0 0 0.36916f
.ends
