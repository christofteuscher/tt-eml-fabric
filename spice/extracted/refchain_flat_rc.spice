* NGSPICE file created from refchain.ext - technology: sky130A

.subckt refchain
X0 vdd.t15 vdd.t13 a_7020_600.t0 vdd.t14 sky130_fd_pr__pfet_g5v0d10v5 ad=8.8 pd=18.2 as=4.4 ps=9.1 w=8 l=1
X1 a_4020_n2480.t8 vcasc a_4440_600.t0 vdd.t21 sky130_fd_pr__pfet_g5v0d10v5 ad=8.8 pd=18.2 as=4.4 ps=9.1 w=8 l=1
X2 vgu.t1 a_7400_n2280.t3 w_80_n2826.t23 w_80_n2826.t22 sky130_fd_pr__nfet_g5v0d10v5 ad=8.8 pd=18.2 as=4.4 ps=9.1 w=8 l=2
X3 vg4.t2 vcasc a_200_n2280.t1 vdd.t18 sky130_fd_pr__pfet_g5v0d10v5 ad=4.4 pd=9.1 as=8.8 ps=18.2 w=8 l=1
X4 a_4440_600.t1 vg4.t3 vdd.t3 vdd.t2 sky130_fd_pr__pfet_g5v0d10v5 ad=4.4 pd=9.1 as=4.4 ps=9.1 w=8 l=2
X5 a_1860_600.t0 vgu.t3 vdd.t7 vdd.t6 sky130_fd_pr__pfet_g5v0d10v5 ad=4.4 pd=9.1 as=4.4 ps=9.1 w=8 l=2
X6 a_420_n2480.t5 a_420_n2480.t4 w_80_n2826.t1 w_80_n2826.t0 sky130_fd_pr__nfet_g5v0d10v5 ad=4.4 pd=9.1 as=4.4 ps=9.1 w=8 l=2
X7 w_80_n2826.t21 a_7400_n2280.t1 a_7400_n2280.t2 w_80_n2826.t20 sky130_fd_pr__nfet_g5v0d10v5 ad=4.4 pd=9.1 as=8.8 ps=18.2 w=8 l=2
X8 a_7400_n2280.t0 pbias vdd.t17 vdd.t16 sky130_fd_pr__pfet_g5v0d10v5 ad=4.4 pd=10.2 as=4.4 ps=10.2 w=4 l=8
X9 w_80_n2826.t7 a_420_n2480.t6 a_420_n2480.t7 w_80_n2826.t6 sky130_fd_pr__nfet_g5v0d10v5 ad=4.4 pd=9.1 as=4.4 ps=9.1 w=8 l=2
X10 a_420_n2480.t1 a_420_n2480.t0 w_80_n2826.t5 w_80_n2826.t4 sky130_fd_pr__nfet_g5v0d10v5 ad=4.4 pd=9.1 as=4.4 ps=9.1 w=8 l=2
X11 vdd.t1 vg4.t0 vg4.t1 vdd.t0 sky130_fd_pr__pfet_g5v0d10v5 ad=4.4 pd=9.1 as=4.4 ps=9.1 w=8 l=2
X12 a_5780_600.t0 vcasc vgu.t0 vdd.t22 sky130_fd_pr__pfet_g5v0d10v5 ad=4.4 pd=9.1 as=8.8 ps=18.2 w=8 l=1
X13 a_7020_600.t1 vdd.t10 vdd.t12 vdd.t11 sky130_fd_pr__pfet_g5v0d10v5 ad=4.4 pd=9.1 as=4.4 ps=9.1 w=8 l=2
X14 vg16.t2 vcasc a_2780_600.t1 vdd.t20 sky130_fd_pr__pfet_g5v0d10v5 ad=4.4 pd=9.1 as=8.8 ps=18.2 w=8 l=1
X15 w_80_n2826.t9 a_420_n2480.t2 a_420_n2480.t3 w_80_n2826.t8 sky130_fd_pr__nfet_g5v0d10v5 ad=8.8 pd=18.2 as=4.4 ps=9.1 w=8 l=2
X16 w_80_n2826.t3 a_420_n2480.t9 a_200_n2280.t0 w_80_n2826.t2 sky130_fd_pr__nfet_g5v0d10v5 ad=4.4 pd=9.1 as=8.8 ps=18.2 w=8 l=2
X17 a_4020_n2480.t5 a_4020_n2480.t4 w_80_n2826.t17 w_80_n2826.t16 sky130_fd_pr__nfet_g5v0d10v5 ad=4.4 pd=9.1 as=4.4 ps=9.1 w=8 l=2
X18 a_420_n2480.t8 vcasc a_1860_600.t1 vdd.t19 sky130_fd_pr__pfet_g5v0d10v5 ad=8.8 pd=18.2 as=4.4 ps=9.1 w=8 l=1
X19 w_80_n2826.t15 a_4020_n2480.t2 a_4020_n2480.t3 w_80_n2826.t14 sky130_fd_pr__nfet_g5v0d10v5 ad=4.4 pd=9.1 as=4.4 ps=9.1 w=8 l=2
X20 vdd.t5 vg16.t0 vg16.t1 vdd.t4 sky130_fd_pr__pfet_g5v0d10v5 ad=4.4 pd=9.1 as=4.4 ps=9.1 w=8 l=2
X21 vdd.t9 vgu.t2 a_5780_600.t1 vdd.t8 sky130_fd_pr__pfet_g5v0d10v5 ad=4.4 pd=9.1 as=4.4 ps=9.1 w=8 l=2
X22 a_4020_n2480.t1 a_4020_n2480.t0 w_80_n2826.t13 w_80_n2826.t12 sky130_fd_pr__nfet_g5v0d10v5 ad=4.4 pd=9.1 as=4.4 ps=9.1 w=8 l=2
X23 w_80_n2826.t11 a_4020_n2480.t9 a_2780_600.t0 w_80_n2826.t10 sky130_fd_pr__nfet_g5v0d10v5 ad=4.4 pd=9.1 as=8.8 ps=18.2 w=8 l=2
X24 w_80_n2826.t19 a_4020_n2480.t6 a_4020_n2480.t7 w_80_n2826.t18 sky130_fd_pr__nfet_g5v0d10v5 ad=8.8 pd=18.2 as=4.4 ps=9.1 w=8 l=2
R0 a_7400_n2280.t0 a_7400_n2280.n0 128.782
R1 a_7400_n2280.n0 a_7400_n2280.n1 1.39875
R2 a_7400_n2280.n1 a_7400_n2280.t1 281.358
R3 a_7400_n2280.n1 a_7400_n2280.t3 281.721
R4 a_7400_n2280.n0 a_7400_n2280.t2 29.8748
R5 a_7020_600.t0 a_7020_600.t1 26.263
R6 a_5780_600.t0 a_5780_600.t1 26.263
R7 a_4020_n2480.t1 a_4020_n2480.n0 7.838
R8 a_4020_n2480.n0 a_4020_n2480.t3 7.838
R9 a_4020_n2480.n0 a_4020_n2480.n1 22.253
R10 a_4020_n2480.n1 a_4020_n2480.n6 0.17675
R11 a_4020_n2480.n6 a_4020_n2480.n5 0.36475
R12 a_4020_n2480.n6 a_4020_n2480.t2 281.358
R13 a_4020_n2480.n5 a_4020_n2480.t4 281.358
R14 a_4020_n2480.n5 a_4020_n2480.n4 0.17675
R15 a_4020_n2480.n4 a_4020_n2480.t6 281.534
R16 a_4020_n2480.n4 a_4020_n2480.n3 22.2525
R17 a_4020_n2480.n3 a_4020_n2480.t5 7.838
R18 a_4020_n2480.n3 a_4020_n2480.t7 7.838
R19 a_4020_n2480.n1 a_4020_n2480.n2 0.17675
R20 a_4020_n2480.n2 a_4020_n2480.t9 281.721
R21 a_4020_n2480.n2 a_4020_n2480.t0 281.358
R22 a_4020_n2480.n1 a_4020_n2480.t8 70.4448
R23 a_4440_600.t0 a_4440_600.t1 26.263
R24 a_2780_600.t0 a_2780_600.t1 101.608
R25 a_420_n2480.t1 a_420_n2480.n0 7.838
R26 a_420_n2480.n0 a_420_n2480.t7 7.838
R27 a_420_n2480.n0 a_420_n2480.n7 22.253
R28 a_420_n2480.n7 a_420_n2480.n6 0.17675
R29 a_420_n2480.n6 a_420_n2480.t6 281.358
R30 a_420_n2480.n6 a_420_n2480.n5 0.344188
R31 a_420_n2480.n5 a_420_n2480.t4 281.38
R32 a_420_n2480.n5 a_420_n2480.n2 0.024
R33 a_420_n2480.n2 a_420_n2480.n4 0.118
R34 a_420_n2480.n4 a_420_n2480.t2 281.534
R35 a_420_n2480.n4 a_420_n2480.n3 22.2525
R36 a_420_n2480.n3 a_420_n2480.t5 7.838
R37 a_420_n2480.n3 a_420_n2480.t3 7.838
R38 a_420_n2480.n2 a_420_n2480.t8 70.4448
R39 a_420_n2480.n7 a_420_n2480.n1 0.17675
R40 a_420_n2480.n1 a_420_n2480.t9 281.721
R41 a_420_n2480.n1 a_420_n2480.t0 281.358
R42 a_1860_600.t0 a_1860_600.t1 26.263
R43 a_200_n2280.t0 a_200_n2280.t1 98.7283
R44 vg16.n0 vg16.t2 13.1318
R45 vg16.n0 vg16.t1 13.1318
R46 vg16.n1 vg16.n0 52.7919
R47 vg16 vg16.n1 16.008
R48 vg16.n1 vg16.t0 285.209
R49 vgu.n0 vgu.t0 70.9486
R50 vgu.n2 vgu.n0 5.70175
R51 vgu vgu.n2 7.99238
R52 vgu.n2 vgu.n1 3.95362
R53 vgu.n1 vgu.t3 292.459
R54 vgu.n1 vgu.t2 285.397
R55 vgu.n0 vgu.t1 30.0905
R56 vg4.n0 vg4.t2 13.1318
R57 vg4.n0 vg4.t1 13.1318
R58 vg4.n1 vg4.n0 52.8859
R59 vg4.n2 vg4.n1 4.96925
R60 vg4 vg4.n2 14.6642
R61 vg4.n2 vg4.t3 285.303
R62 vg4.n1 vg4.t0 285.303
R63 vdd.t15 vdd.n361 54.4093
R64 vdd.n0 vdd.n1 4.28224
R65 vdd.n3 vdd.n2 9.3005
R66 vdd.n5 vdd.n4 9.3005
R67 vdd.n7 vdd.n6 9.3005
R68 vdd.n9 vdd.n8 9.3005
R69 vdd.n11 vdd.n10 9.3005
R70 vdd.n13 vdd.n12 9.3005
R71 vdd.n15 vdd.n14 9.3005
R72 vdd.n17 vdd.n16 9.3005
R73 vdd.n19 vdd.n18 9.3005
R74 vdd.n21 vdd.n20 9.3005
R75 vdd.n23 vdd.n22 9.3005
R76 vdd.n25 vdd.n24 9.3005
R77 vdd.n27 vdd.n26 9.3005
R78 vdd.n29 vdd.n28 9.3005
R79 vdd.n31 vdd.n30 9.3005
R80 vdd.n33 vdd.n32 9.3005
R81 vdd.n35 vdd.n34 9.3005
R82 vdd.n37 vdd.n36 9.3005
R83 vdd.n39 vdd.n38 9.3005
R84 vdd.n41 vdd.n40 9.3005
R85 vdd.n43 vdd.n42 9.3005
R86 vdd.n45 vdd.n44 9.3005
R87 vdd.n47 vdd.n46 9.3005
R88 vdd.n49 vdd.n48 9.3005
R89 vdd.n51 vdd.n50 9.3005
R90 vdd.n53 vdd.n52 9.3005
R91 vdd.n55 vdd.n54 9.3005
R92 vdd.n57 vdd.n56 9.3005
R93 vdd.n59 vdd.n58 9.3005
R94 vdd.n61 vdd.n60 9.3005
R95 vdd.n63 vdd.n62 9.3005
R96 vdd.n65 vdd.n64 9.3005
R97 vdd.n67 vdd.n66 9.3005
R98 vdd.n69 vdd.n68 9.3005
R99 vdd.n72 vdd.n70 9.3005
R100 vdd.n74 vdd.n73 9.3005
R101 vdd.n76 vdd.n75 9.3005
R102 vdd.n78 vdd.n77 9.3005
R103 vdd.n80 vdd.n79 9.3005
R104 vdd.n82 vdd.n81 9.3005
R105 vdd.n84 vdd.n83 9.3005
R106 vdd.n86 vdd.n85 9.3005
R107 vdd.n88 vdd.n87 9.3005
R108 vdd.n90 vdd.n89 9.3005
R109 vdd.n92 vdd.n91 9.3005
R110 vdd.n94 vdd.n93 9.3005
R111 vdd.n96 vdd.n95 9.3005
R112 vdd.n98 vdd.n97 9.3005
R113 vdd.n100 vdd.n99 9.3005
R114 vdd.n102 vdd.n101 9.3005
R115 vdd.n104 vdd.n103 9.3005
R116 vdd.n106 vdd.n105 9.3005
R117 vdd.n108 vdd.n107 9.3005
R118 vdd.n110 vdd.n109 9.3005
R119 vdd.n112 vdd.n111 9.3005
R120 vdd.n114 vdd.n113 9.3005
R121 vdd.n116 vdd.n115 9.3005
R122 vdd.n118 vdd.n117 9.3005
R123 vdd.n120 vdd.n119 9.3005
R124 vdd.n122 vdd.n121 9.3005
R125 vdd.n124 vdd.n123 9.3005
R126 vdd.n126 vdd.n125 9.3005
R127 vdd.n128 vdd.n127 9.3005
R128 vdd.n130 vdd.n129 9.3005
R129 vdd.n134 vdd.n133 9.3005
R130 vdd.n136 vdd.n135 9.3005
R131 vdd.n138 vdd.n137 9.3005
R132 vdd.n140 vdd.n139 9.3005
R133 vdd.n142 vdd.n141 9.3005
R134 vdd.n144 vdd.n143 9.3005
R135 vdd.n361 vdd.n145 9.3005
R136 vdd.n3 vdd.n0 2.68753
R137 vdd.n5 vdd.n3 0.15675
R138 vdd.n7 vdd.n5 0.15675
R139 vdd.n9 vdd.n7 0.15675
R140 vdd.n11 vdd.n9 0.15675
R141 vdd.n13 vdd.n11 0.15675
R142 vdd.n15 vdd.n13 0.15675
R143 vdd.n17 vdd.n15 0.15675
R144 vdd.n19 vdd.n17 0.15675
R145 vdd vdd.n19 0.03175
R146 vdd vdd.n21 0.1255
R147 vdd.n21 vdd.n23 0.15675
R148 vdd.n23 vdd.n25 0.15675
R149 vdd.n25 vdd.n27 0.15675
R150 vdd.n27 vdd.n29 0.15675
R151 vdd.n29 vdd.n31 0.15675
R152 vdd.n31 vdd.n33 0.15675
R153 vdd.n33 vdd.n35 0.15675
R154 vdd.n35 vdd.n37 0.15675
R155 vdd.n37 vdd.n39 0.15675
R156 vdd.n39 vdd.n41 0.15675
R157 vdd.n41 vdd.n43 0.15675
R158 vdd.n43 vdd.n45 0.15675
R159 vdd.n45 vdd.n47 0.15675
R160 vdd.n47 vdd.n49 0.15675
R161 vdd.n49 vdd.n51 0.15675
R162 vdd.n51 vdd.n53 0.15675
R163 vdd.n53 vdd.n55 0.15675
R164 vdd.n55 vdd.n57 0.15675
R165 vdd.n57 vdd.n59 0.15675
R166 vdd.n59 vdd.n61 0.15675
R167 vdd.n61 vdd.n63 0.15675
R168 vdd.n63 vdd.n65 0.15675
R169 vdd.n65 vdd.n67 0.15675
R170 vdd.n67 vdd.n69 0.15675
R171 vdd.n69 vdd.n72 0.15675
R172 vdd.n72 vdd.n74 0.15675
R173 vdd.n74 vdd.n76 0.15675
R174 vdd.n76 vdd.n78 0.15675
R175 vdd.n78 vdd.n80 0.15675
R176 vdd.n80 vdd.n82 0.15675
R177 vdd.n82 vdd.n84 0.15675
R178 vdd.n84 vdd.n86 0.15675
R179 vdd.n86 vdd.n88 0.15675
R180 vdd.n88 vdd.n90 0.15675
R181 vdd.n90 vdd.n92 0.15675
R182 vdd.n92 vdd.n94 0.15675
R183 vdd.n94 vdd.n96 0.15675
R184 vdd.n96 vdd.n98 0.15675
R185 vdd.n98 vdd.n100 0.15675
R186 vdd.n100 vdd.n102 0.15675
R187 vdd.n102 vdd.n104 0.15675
R188 vdd.n104 vdd.n106 0.15675
R189 vdd.n106 vdd.n108 0.15675
R190 vdd.n108 vdd.n110 0.15675
R191 vdd.n110 vdd.n112 0.15675
R192 vdd.n112 vdd.n114 0.15675
R193 vdd.n114 vdd.n116 0.15675
R194 vdd.n116 vdd.n118 0.15675
R195 vdd.n118 vdd.n120 0.15675
R196 vdd.n120 vdd.n122 0.15675
R197 vdd.n122 vdd.n363 0.1255
R198 vdd.n363 vdd.n124 0.03175
R199 vdd.n124 vdd.n126 0.15675
R200 vdd.n126 vdd.n128 0.15675
R201 vdd.n128 vdd.n131 0.141125
R202 vdd.n131 vdd.n130 0.016125
R203 vdd.n130 vdd.n134 0.15675
R204 vdd.n134 vdd.n136 0.15675
R205 vdd.n136 vdd.n138 0.15675
R206 vdd.n138 vdd.n140 0.15675
R207 vdd.n140 vdd.n142 0.15675
R208 vdd.n142 vdd.n132 0.016125
R209 vdd.n132 vdd.n144 0.141125
R210 vdd.n144 vdd.n361 0.15675
R211 vdd vdd.n364 41.2469
R212 vdd.n364 vdd.t1 13.1318
R213 vdd.n364 vdd.t7 13.1318
R214 vdd.n363 vdd.n362 41.2469
R215 vdd.n362 vdd.t9 13.1318
R216 vdd.n362 vdd.t12 13.1318
R217 vdd.n147 vdd.n146 40.2811
R218 vdd.n1 vdd.n147 185
R219 vdd.n148 vdd.n149 185
R220 vdd.n2 vdd.n149 185
R221 vdd.n151 vdd.n150 185
R222 vdd.n4 vdd.n151 185
R223 vdd.n153 vdd.n152 185
R224 vdd.n6 vdd.n153 185
R225 vdd.n155 vdd.n154 185
R226 vdd.n8 vdd.n155 185
R227 vdd.n157 vdd.n156 185
R228 vdd.n10 vdd.n157 185
R229 vdd.n159 vdd.n158 185
R230 vdd.n12 vdd.n159 185
R231 vdd.n161 vdd.n160 185
R232 vdd.n14 vdd.n161 185
R233 vdd.n163 vdd.n162 185
R234 vdd.n16 vdd.n163 185
R235 vdd.n165 vdd.n164 185
R236 vdd.n18 vdd.n165 185
R237 vdd.n167 vdd.n166 185
R238 vdd.n20 vdd.n167 185
R239 vdd.n169 vdd.n168 185
R240 vdd.n22 vdd.n169 185
R241 vdd.n171 vdd.n170 185
R242 vdd.n24 vdd.n171 185
R243 vdd.n173 vdd.n172 185
R244 vdd.n26 vdd.n173 185
R245 vdd.n175 vdd.n174 185
R246 vdd.n28 vdd.n175 185
R247 vdd.n177 vdd.n176 185
R248 vdd.n30 vdd.n177 185
R249 vdd.n179 vdd.n178 185
R250 vdd.n32 vdd.n179 185
R251 vdd.n181 vdd.n180 185
R252 vdd.n34 vdd.n181 185
R253 vdd.n183 vdd.n182 185
R254 vdd.n36 vdd.n183 185
R255 vdd.n185 vdd.n184 185
R256 vdd.n38 vdd.n185 185
R257 vdd.n187 vdd.n186 185
R258 vdd.n40 vdd.n187 185
R259 vdd.n189 vdd.n188 185
R260 vdd.n42 vdd.n189 185
R261 vdd.n191 vdd.n190 185
R262 vdd.n44 vdd.n191 185
R263 vdd.n193 vdd.n192 185
R264 vdd.n46 vdd.n193 185
R265 vdd.n195 vdd.n194 185
R266 vdd.n48 vdd.n195 185
R267 vdd.n197 vdd.n196 185
R268 vdd.n50 vdd.n197 185
R269 vdd.n199 vdd.n198 185
R270 vdd.n52 vdd.n199 185
R271 vdd.n201 vdd.n200 185
R272 vdd.n54 vdd.n201 185
R273 vdd.n203 vdd.n202 185
R274 vdd.n56 vdd.n203 185
R275 vdd.n205 vdd.n204 185
R276 vdd.n58 vdd.n205 185
R277 vdd.n207 vdd.n206 185
R278 vdd.n60 vdd.n207 185
R279 vdd.n209 vdd.n208 185
R280 vdd.n62 vdd.n209 185
R281 vdd.n211 vdd.n210 185
R282 vdd.n64 vdd.n211 185
R283 vdd.n213 vdd.n212 185
R284 vdd.n66 vdd.n213 185
R285 vdd.n215 vdd.n214 185
R286 vdd.n68 vdd.n215 185
R287 vdd.n217 vdd.n216 185
R288 vdd.n70 vdd.n217 185
R289 vdd.n219 vdd.n218 185
R290 vdd.n73 vdd.n219 185
R291 vdd.n221 vdd.n220 185
R292 vdd.n75 vdd.n221 185
R293 vdd.n223 vdd.n222 185
R294 vdd.n77 vdd.n223 185
R295 vdd.n225 vdd.n224 185
R296 vdd.n79 vdd.n225 185
R297 vdd.n227 vdd.n226 185
R298 vdd.n81 vdd.n227 185
R299 vdd.n229 vdd.n228 185
R300 vdd.n83 vdd.n229 185
R301 vdd.n231 vdd.n230 185
R302 vdd.n85 vdd.n231 185
R303 vdd.n233 vdd.n232 185
R304 vdd.n87 vdd.n233 185
R305 vdd.n235 vdd.n234 185
R306 vdd.n89 vdd.n235 185
R307 vdd.n237 vdd.n236 185
R308 vdd.n91 vdd.n237 185
R309 vdd.n239 vdd.n238 185
R310 vdd.n93 vdd.n239 185
R311 vdd.n241 vdd.n240 185
R312 vdd.n95 vdd.n241 185
R313 vdd.n243 vdd.n242 185
R314 vdd.n97 vdd.n243 185
R315 vdd.n245 vdd.n244 185
R316 vdd.n99 vdd.n245 185
R317 vdd.n247 vdd.n246 185
R318 vdd.n101 vdd.n247 185
R319 vdd.n249 vdd.n248 185
R320 vdd.n103 vdd.n249 185
R321 vdd.n251 vdd.n250 185
R322 vdd.n105 vdd.n251 185
R323 vdd.n253 vdd.n252 185
R324 vdd.n107 vdd.n253 185
R325 vdd.n255 vdd.n254 185
R326 vdd.n109 vdd.n255 185
R327 vdd.n257 vdd.n256 185
R328 vdd.n111 vdd.n257 185
R329 vdd.n259 vdd.n258 185
R330 vdd.n113 vdd.n259 185
R331 vdd.n261 vdd.n260 185
R332 vdd.n115 vdd.n261 185
R333 vdd.n263 vdd.n262 185
R334 vdd.n117 vdd.n263 185
R335 vdd.n265 vdd.n264 185
R336 vdd.n119 vdd.n265 185
R337 vdd.n267 vdd.n266 185
R338 vdd.n121 vdd.n267 185
R339 vdd.n269 vdd.n268 185
R340 vdd.n123 vdd.n269 185
R341 vdd.n271 vdd.n270 185
R342 vdd.n125 vdd.n271 185
R343 vdd.n273 vdd.n272 185
R344 vdd.n127 vdd.n273 185
R345 vdd.n275 vdd.n274 185
R346 vdd.n129 vdd.n275 185
R347 vdd.n277 vdd.n276 185
R348 vdd.n133 vdd.n277 185
R349 vdd.n279 vdd.n278 185
R350 vdd.n135 vdd.n279 185
R351 vdd.n281 vdd.n280 185
R352 vdd.n137 vdd.n281 185
R353 vdd.n283 vdd.n282 185
R354 vdd.n139 vdd.n283 185
R355 vdd.n285 vdd.n284 185
R356 vdd.n141 vdd.n285 185
R357 vdd.n287 vdd.n286 185
R358 vdd.n143 vdd.n287 185
R359 vdd.n360 vdd.n359 185
R360 vdd.n145 vdd.n360 185
R361 vdd.n146 vdd.n0 238.254
R362 vdd.n1 vdd.n2 16.0005
R363 vdd.n2 vdd.n4 16.0005
R364 vdd.n4 vdd.n6 16.0005
R365 vdd.n6 vdd.n8 16.0005
R366 vdd.n8 vdd.n10 16.0005
R367 vdd.n10 vdd.n12 16.0005
R368 vdd.n12 vdd.n14 16.0005
R369 vdd.n14 vdd.n16 16.0005
R370 vdd.n16 vdd.n18 16.0005
R371 vdd.n18 vdd.n20 16.0005
R372 vdd.n20 vdd.n22 16.0005
R373 vdd.n22 vdd.n24 16.0005
R374 vdd.n24 vdd.n26 16.0005
R375 vdd.n26 vdd.n28 16.0005
R376 vdd.n28 vdd.n30 16.0005
R377 vdd.n30 vdd.n32 16.0005
R378 vdd.n32 vdd.n34 16.0005
R379 vdd.n34 vdd.n36 16.0005
R380 vdd.n36 vdd.n38 16.0005
R381 vdd.n38 vdd.n40 16.0005
R382 vdd.n40 vdd.n42 16.0005
R383 vdd.n42 vdd.n44 16.0005
R384 vdd.n44 vdd.n46 16.0005
R385 vdd.n46 vdd.n48 16.0005
R386 vdd.n48 vdd.n50 16.0005
R387 vdd.n50 vdd.n52 16.0005
R388 vdd.n52 vdd.n54 16.0005
R389 vdd.n54 vdd.n56 16.0005
R390 vdd.n56 vdd.n58 16.0005
R391 vdd.n58 vdd.n60 16.0005
R392 vdd.n60 vdd.n62 16.0005
R393 vdd.n62 vdd.n64 16.0005
R394 vdd.n64 vdd.n66 16.0005
R395 vdd.n66 vdd.n68 16.0005
R396 vdd.n68 vdd.n70 16.0005
R397 vdd.n70 vdd.n73 16.0005
R398 vdd.n73 vdd.n75 16.0005
R399 vdd.n75 vdd.n77 16.0005
R400 vdd.n77 vdd.n79 16.0005
R401 vdd.n79 vdd.n81 16.0005
R402 vdd.n81 vdd.n83 16.0005
R403 vdd.n83 vdd.n85 16.0005
R404 vdd.n85 vdd.n87 16.0005
R405 vdd.n87 vdd.n89 16.0005
R406 vdd.n89 vdd.n91 16.0005
R407 vdd.n91 vdd.n93 16.0005
R408 vdd.n93 vdd.n95 16.0005
R409 vdd.n95 vdd.n97 16.0005
R410 vdd.n97 vdd.n99 16.0005
R411 vdd.n99 vdd.n101 16.0005
R412 vdd.n101 vdd.n103 16.0005
R413 vdd.n103 vdd.n105 16.0005
R414 vdd.n105 vdd.n107 16.0005
R415 vdd.n107 vdd.n109 16.0005
R416 vdd.n109 vdd.n111 16.0005
R417 vdd.n111 vdd.n113 16.0005
R418 vdd.n113 vdd.n115 16.0005
R419 vdd.n115 vdd.n117 16.0005
R420 vdd.n117 vdd.n119 16.0005
R421 vdd.n119 vdd.n121 16.0005
R422 vdd.n121 vdd.n123 16.0005
R423 vdd.n123 vdd.n125 16.0005
R424 vdd.n125 vdd.n127 16.0005
R425 vdd.n127 vdd.n129 16.0005
R426 vdd.n129 vdd.n133 16.0005
R427 vdd.n133 vdd.n135 16.0005
R428 vdd.n135 vdd.n137 16.0005
R429 vdd.n137 vdd.n139 16.0005
R430 vdd.n139 vdd.n141 16.0005
R431 vdd.n141 vdd.n143 16.0005
R432 vdd.n143 vdd.n145 16.0005
R433 vdd.n147 vdd.n149 114.001
R434 vdd.n149 vdd.n151 114.001
R435 vdd.n151 vdd.n153 114.001
R436 vdd.n153 vdd.n155 114.001
R437 vdd.n155 vdd.n157 114.001
R438 vdd.n157 vdd.n159 114.001
R439 vdd.n159 vdd.n161 114.001
R440 vdd.n161 vdd.n163 114.001
R441 vdd.n163 vdd.n165 114.001
R442 vdd.n165 vdd.n167 114.001
R443 vdd.n167 vdd.n169 114.001
R444 vdd.n169 vdd.n171 114.001
R445 vdd.n171 vdd.n173 114.001
R446 vdd.n173 vdd.n175 114.001
R447 vdd.n175 vdd.n177 114.001
R448 vdd.n177 vdd.n179 114.001
R449 vdd.n179 vdd.n181 114.001
R450 vdd.n181 vdd.n183 114.001
R451 vdd.n183 vdd.n185 114.001
R452 vdd.n185 vdd.n187 114.001
R453 vdd.n187 vdd.n189 114.001
R454 vdd.n189 vdd.n191 114.001
R455 vdd.n191 vdd.n193 114.001
R456 vdd.n193 vdd.n195 114.001
R457 vdd.n195 vdd.n197 114.001
R458 vdd.n197 vdd.n199 114.001
R459 vdd.n199 vdd.n201 114.001
R460 vdd.n201 vdd.n203 114.001
R461 vdd.n203 vdd.n205 114.001
R462 vdd.n205 vdd.n207 114.001
R463 vdd.n207 vdd.n209 114.001
R464 vdd.n209 vdd.n211 114.001
R465 vdd.n211 vdd.n213 114.001
R466 vdd.n213 vdd.n215 114.001
R467 vdd.n215 vdd.n217 114.001
R468 vdd.n217 vdd.n219 114.001
R469 vdd.n219 vdd.n221 114.001
R470 vdd.n221 vdd.n223 114.001
R471 vdd.n223 vdd.n225 114.001
R472 vdd.n225 vdd.n227 114.001
R473 vdd.n227 vdd.n229 114.001
R474 vdd.n229 vdd.n231 114.001
R475 vdd.n231 vdd.n233 114.001
R476 vdd.n233 vdd.n235 114.001
R477 vdd.n235 vdd.n237 114.001
R478 vdd.n237 vdd.n239 114.001
R479 vdd.n239 vdd.n241 114.001
R480 vdd.n241 vdd.n243 114.001
R481 vdd.n243 vdd.n245 114.001
R482 vdd.n245 vdd.n247 114.001
R483 vdd.n247 vdd.n249 114.001
R484 vdd.n249 vdd.n251 114.001
R485 vdd.n251 vdd.n253 114.001
R486 vdd.n253 vdd.n255 114.001
R487 vdd.n255 vdd.n257 114.001
R488 vdd.n257 vdd.n259 114.001
R489 vdd.n259 vdd.n261 114.001
R490 vdd.n261 vdd.n263 114.001
R491 vdd.n263 vdd.n265 114.001
R492 vdd.n265 vdd.n267 114.001
R493 vdd.n267 vdd.n269 114.001
R494 vdd.n269 vdd.n271 114.001
R495 vdd.n271 vdd.n273 114.001
R496 vdd.n273 vdd.n275 114.001
R497 vdd.n275 vdd.n277 114.001
R498 vdd.n277 vdd.n279 114.001
R499 vdd.n279 vdd.n281 114.001
R500 vdd.n281 vdd.n283 114.001
R501 vdd.n283 vdd.n285 114.001
R502 vdd.n285 vdd.n287 114.001
R503 vdd.n287 vdd.n360 114.001
R504 vdd.n289 vdd.n288 40.2811
R505 vdd.n290 vdd.n289 185
R506 vdd.n291 vdd.n292 185
R507 vdd.n293 vdd.n292 185
R508 vdd.n294 vdd.n295 185
R509 vdd.n296 vdd.n295 185
R510 vdd.n297 vdd.n298 185
R511 vdd.n299 vdd.n298 185
R512 vdd.n300 vdd.n301 185
R513 vdd.n302 vdd.n301 185
R514 vdd.n303 vdd.n304 185
R515 vdd.n305 vdd.n304 185
R516 vdd.n306 vdd.n307 185
R517 vdd.n308 vdd.n307 185
R518 vdd.n309 vdd.n310 185
R519 vdd.n311 vdd.n310 185
R520 vdd.t16 vdd.n312 185
R521 vdd.n312 vdd.n313 185
R522 vdd.n314 vdd.n315 185
R523 vdd.n315 vdd.n316 185
R524 vdd.n317 vdd.n318 185
R525 vdd.n318 vdd.n319 185
R526 vdd.n320 vdd.n321 185
R527 vdd.n321 vdd.n322 185
R528 vdd.n323 vdd.n324 185
R529 vdd.n324 vdd.n325 185
R530 vdd.n326 vdd.n327 185
R531 vdd.n327 vdd.n328 185
R532 vdd.n329 vdd.n330 185
R533 vdd.n330 vdd.n331 185
R534 vdd.n332 vdd.n333 185
R535 vdd.n333 vdd.n334 185
R536 vdd.n335 vdd.n336 185
R537 vdd.n336 vdd.n337 185
R538 vdd.n338 vdd.n339 185
R539 vdd.n339 vdd.n340 185
R540 vdd.n146 vdd.t18 114.98
R541 vdd.t18 vdd.n148 3.95883
R542 vdd.n148 vdd.n150 39.5838
R543 vdd.n150 vdd.n152 39.5838
R544 vdd.n152 vdd.n154 39.5838
R545 vdd.n154 vdd.n156 39.5838
R546 vdd.n156 vdd.n158 39.5838
R547 vdd.n158 vdd.t0 3.95883
R548 vdd.t0 vdd.n160 35.6255
R549 vdd.n160 vdd.n162 39.5838
R550 vdd.n162 vdd.n164 39.5838
R551 vdd.n164 vdd.n166 39.5838
R552 vdd.n166 vdd.n168 39.5838
R553 vdd.n168 vdd.n170 39.5838
R554 vdd.n170 vdd.t6 11.8755
R555 vdd.t6 vdd.n172 27.7088
R556 vdd.n172 vdd.n174 39.5838
R557 vdd.n174 vdd.n176 39.5838
R558 vdd.n176 vdd.n178 39.5838
R559 vdd.n178 vdd.n180 39.5838
R560 vdd.n180 vdd.t19 19.7922
R561 vdd.t19 vdd.n182 19.7922
R562 vdd.n182 vdd.n184 39.5838
R563 vdd.n184 vdd.n186 39.5838
R564 vdd.n186 vdd.n188 39.5838
R565 vdd.n188 vdd.n190 39.5838
R566 vdd.n190 vdd.n192 39.5838
R567 vdd.n192 vdd.n194 39.5838
R568 vdd.n194 vdd.n196 39.5838
R569 vdd.n196 vdd.n198 39.5838
R570 vdd.n198 vdd.t20 27.7088
R571 vdd.n200 vdd.t20 11.8755
R572 vdd.n200 vdd.n202 39.5838
R573 vdd.n202 vdd.n204 39.5838
R574 vdd.n204 vdd.n206 39.5838
R575 vdd.n206 vdd.n208 39.5838
R576 vdd.n208 vdd.t4 35.6255
R577 vdd.n210 vdd.t4 3.95883
R578 vdd.n210 vdd.n212 39.5838
R579 vdd.n212 vdd.n214 39.5838
R580 vdd.n214 vdd.n216 39.5838
R581 vdd.n216 vdd.n218 39.5838
R582 vdd.n218 vdd.n220 39.5838
R583 vdd.n220 vdd.n222 39.5838
R584 vdd.n222 vdd.t2 3.95883
R585 vdd.t2 vdd.n224 35.6255
R586 vdd.n224 vdd.n226 39.5838
R587 vdd.n226 vdd.n228 39.5838
R588 vdd.n228 vdd.n230 39.5838
R589 vdd.n230 vdd.n232 39.5838
R590 vdd.n232 vdd.t21 11.8755
R591 vdd.t21 vdd.n234 27.7088
R592 vdd.n234 vdd.n236 39.5838
R593 vdd.n236 vdd.n238 39.5838
R594 vdd.n238 vdd.n240 39.5838
R595 vdd.n240 vdd.n242 39.5838
R596 vdd.n242 vdd.n244 39.5838
R597 vdd.n244 vdd.n246 39.5838
R598 vdd.n246 vdd.n248 39.5838
R599 vdd.n248 vdd.n250 39.5838
R600 vdd.n250 vdd.t22 19.7922
R601 vdd.t22 vdd.n252 19.7922
R602 vdd.n252 vdd.n254 39.5838
R603 vdd.n254 vdd.n256 39.5838
R604 vdd.n256 vdd.n258 39.5838
R605 vdd.n258 vdd.n260 39.5838
R606 vdd.n260 vdd.t8 27.7088
R607 vdd.n262 vdd.t8 11.8755
R608 vdd.n262 vdd.n264 39.5838
R609 vdd.n264 vdd.n266 39.5838
R610 vdd.n266 vdd.n268 39.5838
R611 vdd.n268 vdd.n270 39.5838
R612 vdd.n270 vdd.n272 39.5838
R613 vdd.n272 vdd.t11 35.6255
R614 vdd.n274 vdd.t11 3.95883
R615 vdd.n274 vdd.n276 39.5838
R616 vdd.n276 vdd.n278 39.5838
R617 vdd.n278 vdd.n280 39.5838
R618 vdd.n280 vdd.n282 39.5838
R619 vdd.n282 vdd.n284 39.5838
R620 vdd.n284 vdd.t14 3.95883
R621 vdd.t14 vdd.n286 35.6255
R622 vdd.n286 vdd.n359 39.5838
R623 vdd.n359 vdd.n338 209.792
R624 vdd.n338 vdd.n335 39.5838
R625 vdd.n335 vdd.n332 39.5838
R626 vdd.n332 vdd.n329 39.5838
R627 vdd.n329 vdd.n326 39.5838
R628 vdd.n326 vdd.n323 39.5838
R629 vdd.n323 vdd.n320 39.5838
R630 vdd.n320 vdd.n317 39.5838
R631 vdd.n317 vdd.n314 39.5838
R632 vdd.n314 vdd.t16 39.5838
R633 vdd.t16 vdd.n309 39.5838
R634 vdd.n309 vdd.n306 39.5838
R635 vdd.n306 vdd.n303 39.5838
R636 vdd.n303 vdd.n300 39.5838
R637 vdd.n300 vdd.n297 39.5838
R638 vdd.n297 vdd.n294 39.5838
R639 vdd.n294 vdd.n291 39.5838
R640 vdd.n291 vdd.n288 118.938
R641 vdd.n340 vdd.n342 9.3005
R642 vdd.n337 vdd.n343 9.3005
R643 vdd.n344 vdd.n334 9.3005
R644 vdd.n345 vdd.n331 9.3005
R645 vdd.n346 vdd.n328 9.3005
R646 vdd.n347 vdd.n325 9.3005
R647 vdd.n348 vdd.n322 9.3005
R648 vdd.n349 vdd.n319 9.3005
R649 vdd.n350 vdd.n316 9.3005
R650 vdd.n351 vdd.n313 9.3005
R651 vdd.n352 vdd.n311 9.3005
R652 vdd.n353 vdd.n308 9.3005
R653 vdd.n354 vdd.n305 9.3005
R654 vdd.n355 vdd.n302 9.3005
R655 vdd.n356 vdd.n299 9.3005
R656 vdd.n357 vdd.n296 9.3005
R657 vdd.n358 vdd.n293 9.3005
R658 vdd.n341 vdd.n290 4.28224
R659 vdd.n340 vdd.n337 16.0005
R660 vdd.n337 vdd.n334 16.0005
R661 vdd.n334 vdd.n331 16.0005
R662 vdd.n331 vdd.n328 16.0005
R663 vdd.n328 vdd.n325 16.0005
R664 vdd.n325 vdd.n322 16.0005
R665 vdd.n322 vdd.n319 16.0005
R666 vdd.n319 vdd.n316 16.0005
R667 vdd.n316 vdd.n313 16.0005
R668 vdd.n313 vdd.n311 16.0005
R669 vdd.n311 vdd.n308 16.0005
R670 vdd.n308 vdd.n305 16.0005
R671 vdd.n305 vdd.n302 16.0005
R672 vdd.n302 vdd.n299 16.0005
R673 vdd.n299 vdd.n296 16.0005
R674 vdd.n296 vdd.n293 16.0005
R675 vdd.n293 vdd.n290 16.0005
R676 vdd.n342 vdd.n343 0.15675
R677 vdd.n343 vdd.n344 0.15675
R678 vdd.n344 vdd.n345 0.15675
R679 vdd.n345 vdd.n346 0.15675
R680 vdd.n346 vdd.n347 0.15675
R681 vdd.n347 vdd.n348 0.15675
R682 vdd.n348 vdd.n349 0.15675
R683 vdd.n349 vdd.n350 0.15675
R684 vdd.n350 vdd.n351 0.15675
R685 vdd.n351 vdd.n352 0.15675
R686 vdd.n352 vdd.n353 0.15675
R687 vdd.n353 vdd.n354 0.15675
R688 vdd.n354 vdd.n355 0.15675
R689 vdd.n355 vdd.n356 0.15675
R690 vdd.n356 vdd.n357 0.15675
R691 vdd.n357 vdd.n358 0.15675
R692 vdd.n358 vdd.n341 2.68753
R693 vdd.n342 vdd.t17 112.392
R694 vdd.n339 vdd.n336 114.001
R695 vdd.n336 vdd.n333 114.001
R696 vdd.n333 vdd.n330 114.001
R697 vdd.n330 vdd.n327 114.001
R698 vdd.n327 vdd.n324 114.001
R699 vdd.n324 vdd.n321 114.001
R700 vdd.n321 vdd.n318 114.001
R701 vdd.n318 vdd.n315 114.001
R702 vdd.n315 vdd.n312 114.001
R703 vdd.n312 vdd.n310 114.001
R704 vdd.n310 vdd.n307 114.001
R705 vdd.n307 vdd.n304 114.001
R706 vdd.n304 vdd.n301 114.001
R707 vdd.n301 vdd.n298 114.001
R708 vdd.n298 vdd.n295 114.001
R709 vdd.n295 vdd.n292 114.001
R710 vdd.n292 vdd.n289 114.001
R711 vdd.n288 vdd.n341 238.254
R712 vdd.n132 vdd.t13 395.024
R713 vdd.n131 vdd.t10 282.959
R714 vdd.n72 vdd.n71 41.2469
R715 vdd.n71 vdd.t5 13.1318
R716 vdd.n71 vdd.t3 13.1318
R717 w_80_n2826.t19 w_80_n2826.n340 22.3509
R718 w_80_n2826.n1 w_80_n2826.n2 4.28224
R719 w_80_n2826.n4 w_80_n2826.n3 9.3005
R720 w_80_n2826.n6 w_80_n2826.n5 9.3005
R721 w_80_n2826.n8 w_80_n2826.n7 9.3005
R722 w_80_n2826.n10 w_80_n2826.n9 9.3005
R723 w_80_n2826.n13 w_80_n2826.n11 9.3005
R724 w_80_n2826.n15 w_80_n2826.n14 9.3005
R725 w_80_n2826.n17 w_80_n2826.n16 9.3005
R726 w_80_n2826.n19 w_80_n2826.n18 9.3005
R727 w_80_n2826.n21 w_80_n2826.n20 9.3005
R728 w_80_n2826.n23 w_80_n2826.n22 9.3005
R729 w_80_n2826.n25 w_80_n2826.n24 9.3005
R730 w_80_n2826.n27 w_80_n2826.n26 9.3005
R731 w_80_n2826.n29 w_80_n2826.n28 9.3005
R732 w_80_n2826.n31 w_80_n2826.n30 9.3005
R733 w_80_n2826.n33 w_80_n2826.n32 9.3005
R734 w_80_n2826.n35 w_80_n2826.n34 9.3005
R735 w_80_n2826.n37 w_80_n2826.n36 9.3005
R736 w_80_n2826.n39 w_80_n2826.n38 9.3005
R737 w_80_n2826.n41 w_80_n2826.n40 9.3005
R738 w_80_n2826.n43 w_80_n2826.n42 9.3005
R739 w_80_n2826.n45 w_80_n2826.n44 9.3005
R740 w_80_n2826.n47 w_80_n2826.n46 9.3005
R741 w_80_n2826.n49 w_80_n2826.n48 9.3005
R742 w_80_n2826.n51 w_80_n2826.n50 9.3005
R743 w_80_n2826.n53 w_80_n2826.n52 9.3005
R744 w_80_n2826.n55 w_80_n2826.n54 9.3005
R745 w_80_n2826.n57 w_80_n2826.n56 9.3005
R746 w_80_n2826.n59 w_80_n2826.n58 9.3005
R747 w_80_n2826.n61 w_80_n2826.n60 9.3005
R748 w_80_n2826.n63 w_80_n2826.n62 9.3005
R749 w_80_n2826.n65 w_80_n2826.n64 9.3005
R750 w_80_n2826.n67 w_80_n2826.n66 9.3005
R751 w_80_n2826.n69 w_80_n2826.n68 9.3005
R752 w_80_n2826.n71 w_80_n2826.n70 9.3005
R753 w_80_n2826.n73 w_80_n2826.n72 9.3005
R754 w_80_n2826.n75 w_80_n2826.n74 9.3005
R755 w_80_n2826.n77 w_80_n2826.n76 9.3005
R756 w_80_n2826.n79 w_80_n2826.n78 9.3005
R757 w_80_n2826.n81 w_80_n2826.n80 9.3005
R758 w_80_n2826.n83 w_80_n2826.n82 9.3005
R759 w_80_n2826.n86 w_80_n2826.n84 9.3005
R760 w_80_n2826.n88 w_80_n2826.n87 9.3005
R761 w_80_n2826.n90 w_80_n2826.n89 9.3005
R762 w_80_n2826.n92 w_80_n2826.n91 9.3005
R763 w_80_n2826.n94 w_80_n2826.n93 9.3005
R764 w_80_n2826.n96 w_80_n2826.n95 9.3005
R765 w_80_n2826.n98 w_80_n2826.n97 9.3005
R766 w_80_n2826.n100 w_80_n2826.n99 9.3005
R767 w_80_n2826.n102 w_80_n2826.n101 9.3005
R768 w_80_n2826.n104 w_80_n2826.n103 9.3005
R769 w_80_n2826.n106 w_80_n2826.n105 9.3005
R770 w_80_n2826.n108 w_80_n2826.n107 9.3005
R771 w_80_n2826.n110 w_80_n2826.n109 9.3005
R772 w_80_n2826.n112 w_80_n2826.n111 9.3005
R773 w_80_n2826.n114 w_80_n2826.n113 9.3005
R774 w_80_n2826.n116 w_80_n2826.n115 9.3005
R775 w_80_n2826.n118 w_80_n2826.n117 9.3005
R776 w_80_n2826.n120 w_80_n2826.n119 9.3005
R777 w_80_n2826.n122 w_80_n2826.n121 9.3005
R778 w_80_n2826.n124 w_80_n2826.n123 9.3005
R779 w_80_n2826.n126 w_80_n2826.n125 9.3005
R780 w_80_n2826.n128 w_80_n2826.n127 9.3005
R781 w_80_n2826.n130 w_80_n2826.n129 9.3005
R782 w_80_n2826.n132 w_80_n2826.n131 9.3005
R783 w_80_n2826.n134 w_80_n2826.n133 9.3005
R784 w_80_n2826.n136 w_80_n2826.n135 9.3005
R785 w_80_n2826.n138 w_80_n2826.n137 9.3005
R786 w_80_n2826.n140 w_80_n2826.n139 9.3005
R787 w_80_n2826.n142 w_80_n2826.n141 9.3005
R788 w_80_n2826.n144 w_80_n2826.n143 9.3005
R789 w_80_n2826.n146 w_80_n2826.n145 9.3005
R790 w_80_n2826.n148 w_80_n2826.n147 9.3005
R791 w_80_n2826.n150 w_80_n2826.n149 9.3005
R792 w_80_n2826.n152 w_80_n2826.n151 9.3005
R793 w_80_n2826.n154 w_80_n2826.n153 9.3005
R794 w_80_n2826.n156 w_80_n2826.n155 9.3005
R795 w_80_n2826.n159 w_80_n2826.n157 9.3005
R796 w_80_n2826.n161 w_80_n2826.n160 9.3005
R797 w_80_n2826.n163 w_80_n2826.n162 9.3005
R798 w_80_n2826.n165 w_80_n2826.n164 9.3005
R799 w_80_n2826.n167 w_80_n2826.n166 9.3005
R800 w_80_n2826.n0 w_80_n2826.n168 4.28224
R801 w_80_n2826.n4 w_80_n2826.n1 2.68753
R802 w_80_n2826.n6 w_80_n2826.n4 0.15675
R803 w_80_n2826.n8 w_80_n2826.n6 0.15675
R804 w_80_n2826.n10 w_80_n2826.n8 0.15675
R805 w_80_n2826.n13 w_80_n2826.n10 0.15675
R806 w_80_n2826.n15 w_80_n2826.n13 0.15675
R807 w_80_n2826.n17 w_80_n2826.n15 0.15675
R808 w_80_n2826.n19 w_80_n2826.n17 0.15675
R809 w_80_n2826.n21 w_80_n2826.n19 0.15675
R810 w_80_n2826.n23 w_80_n2826.n21 0.15675
R811 w_80_n2826.n25 w_80_n2826.n23 0.15675
R812 w_80_n2826.n27 w_80_n2826.n25 0.15675
R813 w_80_n2826.n29 w_80_n2826.n27 0.15675
R814 w_80_n2826.n31 w_80_n2826.n29 0.15675
R815 w_80_n2826.n33 w_80_n2826.n31 0.15675
R816 w_80_n2826.n35 w_80_n2826.n33 0.15675
R817 w_80_n2826.n37 w_80_n2826.n35 0.15675
R818 w_80_n2826.n339 w_80_n2826.n37 0.063
R819 w_80_n2826.n39 w_80_n2826.n339 0.09425
R820 w_80_n2826.n41 w_80_n2826.n39 0.15675
R821 w_80_n2826.n43 w_80_n2826.n41 0.15675
R822 w_80_n2826.n45 w_80_n2826.n43 0.15675
R823 w_80_n2826.n47 w_80_n2826.n45 0.15675
R824 w_80_n2826.n49 w_80_n2826.n47 0.15675
R825 w_80_n2826.n51 w_80_n2826.n49 0.15675
R826 w_80_n2826.n53 w_80_n2826.n51 0.15675
R827 w_80_n2826.n55 w_80_n2826.n53 0.15675
R828 w_80_n2826.n57 w_80_n2826.n55 0.15675
R829 w_80_n2826.n59 w_80_n2826.n57 0.15675
R830 w_80_n2826.n61 w_80_n2826.n59 0.15675
R831 w_80_n2826.n337 w_80_n2826.n61 0.1255
R832 w_80_n2826.n63 w_80_n2826.n337 0.03175
R833 w_80_n2826.n65 w_80_n2826.n63 0.15675
R834 w_80_n2826.n67 w_80_n2826.n65 0.15675
R835 w_80_n2826.n69 w_80_n2826.n67 0.15675
R836 w_80_n2826.n71 w_80_n2826.n69 0.15675
R837 w_80_n2826.n73 w_80_n2826.n71 0.15675
R838 w_80_n2826.n75 w_80_n2826.n73 0.15675
R839 w_80_n2826.n77 w_80_n2826.n75 0.15675
R840 w_80_n2826.n79 w_80_n2826.n77 0.15675
R841 w_80_n2826.n81 w_80_n2826.n79 0.15675
R842 w_80_n2826.n83 w_80_n2826.n81 0.15675
R843 w_80_n2826.n86 w_80_n2826.n83 0.15675
R844 w_80_n2826.n88 w_80_n2826.n86 0.15675
R845 w_80_n2826.n90 w_80_n2826.n88 0.15675
R846 w_80_n2826.n92 w_80_n2826.n90 0.15675
R847 w_80_n2826.n94 w_80_n2826.n92 0.15675
R848 w_80_n2826.n96 w_80_n2826.n94 0.15675
R849 w_80_n2826.n98 w_80_n2826.n96 0.15675
R850 w_80_n2826.n100 w_80_n2826.n98 0.15675
R851 w_80_n2826.n102 w_80_n2826.n100 0.15675
R852 w_80_n2826.n104 w_80_n2826.n102 0.15675
R853 w_80_n2826.n106 w_80_n2826.n104 0.15675
R854 w_80_n2826.n108 w_80_n2826.n106 0.15675
R855 w_80_n2826.n110 w_80_n2826.n108 0.15675
R856 w_80_n2826.n336 w_80_n2826.n110 0.063
R857 w_80_n2826.n112 w_80_n2826.n336 0.09425
R858 w_80_n2826.n114 w_80_n2826.n112 0.15675
R859 w_80_n2826.n116 w_80_n2826.n114 0.15675
R860 w_80_n2826.n118 w_80_n2826.n116 0.15675
R861 w_80_n2826.n120 w_80_n2826.n118 0.15675
R862 w_80_n2826.n122 w_80_n2826.n120 0.15675
R863 w_80_n2826.n124 w_80_n2826.n122 0.15675
R864 w_80_n2826.n126 w_80_n2826.n124 0.15675
R865 w_80_n2826.n128 w_80_n2826.n126 0.15675
R866 w_80_n2826.n130 w_80_n2826.n128 0.15675
R867 w_80_n2826.n132 w_80_n2826.n130 0.15675
R868 w_80_n2826.n134 w_80_n2826.n132 0.15675
R869 w_80_n2826.n340 w_80_n2826.n134 0.1255
R870 w_80_n2826.n340 w_80_n2826.n136 0.03175
R871 w_80_n2826.n136 w_80_n2826.n138 0.15675
R872 w_80_n2826.n138 w_80_n2826.n140 0.15675
R873 w_80_n2826.n140 w_80_n2826.n142 0.15675
R874 w_80_n2826.n142 w_80_n2826.n144 0.15675
R875 w_80_n2826.n144 w_80_n2826.n146 0.15675
R876 w_80_n2826.n146 w_80_n2826.n148 0.15675
R877 w_80_n2826.n148 w_80_n2826.n150 0.15675
R878 w_80_n2826.n150 w_80_n2826.n152 0.15675
R879 w_80_n2826.n152 w_80_n2826.n154 0.15675
R880 w_80_n2826.n154 w_80_n2826.n156 0.15675
R881 w_80_n2826.n156 w_80_n2826.n159 0.15675
R882 w_80_n2826.n159 w_80_n2826.n161 0.15675
R883 w_80_n2826.n161 w_80_n2826.n163 0.15675
R884 w_80_n2826.n163 w_80_n2826.n165 0.15675
R885 w_80_n2826.n165 w_80_n2826.n167 0.15675
R886 w_80_n2826.n167 w_80_n2826.n0 2.68753
R887 w_80_n2826.n339 w_80_n2826.n338 14.5144
R888 w_80_n2826.n338 w_80_n2826.t7 7.838
R889 w_80_n2826.n338 w_80_n2826.t1 7.838
R890 w_80_n2826.n337 w_80_n2826.t9 22.3519
R891 w_80_n2826.n336 w_80_n2826.n335 14.5144
R892 w_80_n2826.n335 w_80_n2826.t15 7.838
R893 w_80_n2826.n335 w_80_n2826.t17 7.838
R894 w_80_n2826.n170 w_80_n2826.n169 74.7856
R895 w_80_n2826.n168 w_80_n2826.n170 585
R896 w_80_n2826.n171 w_80_n2826.n172 585
R897 w_80_n2826.n166 w_80_n2826.n172 585
R898 w_80_n2826.n174 w_80_n2826.n173 585
R899 w_80_n2826.n164 w_80_n2826.n174 585
R900 w_80_n2826.n176 w_80_n2826.n175 585
R901 w_80_n2826.n162 w_80_n2826.n176 585
R902 w_80_n2826.n178 w_80_n2826.n177 585
R903 w_80_n2826.n160 w_80_n2826.n178 585
R904 w_80_n2826.n180 w_80_n2826.n179 585
R905 w_80_n2826.n157 w_80_n2826.n180 585
R906 w_80_n2826.n182 w_80_n2826.n181 585
R907 w_80_n2826.n155 w_80_n2826.n182 585
R908 w_80_n2826.n184 w_80_n2826.n183 585
R909 w_80_n2826.n153 w_80_n2826.n184 585
R910 w_80_n2826.n186 w_80_n2826.n185 585
R911 w_80_n2826.n151 w_80_n2826.n186 585
R912 w_80_n2826.n188 w_80_n2826.n187 585
R913 w_80_n2826.n149 w_80_n2826.n188 585
R914 w_80_n2826.n190 w_80_n2826.n189 585
R915 w_80_n2826.n147 w_80_n2826.n190 585
R916 w_80_n2826.n192 w_80_n2826.n191 585
R917 w_80_n2826.n145 w_80_n2826.n192 585
R918 w_80_n2826.n194 w_80_n2826.n193 585
R919 w_80_n2826.n143 w_80_n2826.n194 585
R920 w_80_n2826.n196 w_80_n2826.n195 585
R921 w_80_n2826.n141 w_80_n2826.n196 585
R922 w_80_n2826.n198 w_80_n2826.n197 585
R923 w_80_n2826.n139 w_80_n2826.n198 585
R924 w_80_n2826.n200 w_80_n2826.n199 585
R925 w_80_n2826.n137 w_80_n2826.n200 585
R926 w_80_n2826.n202 w_80_n2826.n201 585
R927 w_80_n2826.n135 w_80_n2826.n202 585
R928 w_80_n2826.n204 w_80_n2826.n203 585
R929 w_80_n2826.n133 w_80_n2826.n204 585
R930 w_80_n2826.n206 w_80_n2826.n205 585
R931 w_80_n2826.n131 w_80_n2826.n206 585
R932 w_80_n2826.n208 w_80_n2826.n207 585
R933 w_80_n2826.n129 w_80_n2826.n208 585
R934 w_80_n2826.n210 w_80_n2826.n209 585
R935 w_80_n2826.n127 w_80_n2826.n210 585
R936 w_80_n2826.n212 w_80_n2826.n211 585
R937 w_80_n2826.n125 w_80_n2826.n212 585
R938 w_80_n2826.n214 w_80_n2826.n213 585
R939 w_80_n2826.n123 w_80_n2826.n214 585
R940 w_80_n2826.n216 w_80_n2826.n215 585
R941 w_80_n2826.n121 w_80_n2826.n216 585
R942 w_80_n2826.n218 w_80_n2826.n217 585
R943 w_80_n2826.n119 w_80_n2826.n218 585
R944 w_80_n2826.n220 w_80_n2826.n219 585
R945 w_80_n2826.n117 w_80_n2826.n220 585
R946 w_80_n2826.n222 w_80_n2826.n221 585
R947 w_80_n2826.n115 w_80_n2826.n222 585
R948 w_80_n2826.n224 w_80_n2826.n223 585
R949 w_80_n2826.n113 w_80_n2826.n224 585
R950 w_80_n2826.n226 w_80_n2826.n225 585
R951 w_80_n2826.n111 w_80_n2826.n226 585
R952 w_80_n2826.n228 w_80_n2826.n227 585
R953 w_80_n2826.n109 w_80_n2826.n228 585
R954 w_80_n2826.n230 w_80_n2826.n229 585
R955 w_80_n2826.n107 w_80_n2826.n230 585
R956 w_80_n2826.n232 w_80_n2826.n231 585
R957 w_80_n2826.n105 w_80_n2826.n232 585
R958 w_80_n2826.n234 w_80_n2826.n233 585
R959 w_80_n2826.n103 w_80_n2826.n234 585
R960 w_80_n2826.n236 w_80_n2826.n235 585
R961 w_80_n2826.n101 w_80_n2826.n236 585
R962 w_80_n2826.n238 w_80_n2826.n237 585
R963 w_80_n2826.n99 w_80_n2826.n238 585
R964 w_80_n2826.n240 w_80_n2826.n239 585
R965 w_80_n2826.n97 w_80_n2826.n240 585
R966 w_80_n2826.n242 w_80_n2826.n241 585
R967 w_80_n2826.n95 w_80_n2826.n242 585
R968 w_80_n2826.n244 w_80_n2826.n243 585
R969 w_80_n2826.n93 w_80_n2826.n244 585
R970 w_80_n2826.n246 w_80_n2826.n245 585
R971 w_80_n2826.n91 w_80_n2826.n246 585
R972 w_80_n2826.n248 w_80_n2826.n247 585
R973 w_80_n2826.n89 w_80_n2826.n248 585
R974 w_80_n2826.n250 w_80_n2826.n249 585
R975 w_80_n2826.n87 w_80_n2826.n250 585
R976 w_80_n2826.n252 w_80_n2826.n251 585
R977 w_80_n2826.n84 w_80_n2826.n252 585
R978 w_80_n2826.n254 w_80_n2826.n253 585
R979 w_80_n2826.n82 w_80_n2826.n254 585
R980 w_80_n2826.n256 w_80_n2826.n255 585
R981 w_80_n2826.n80 w_80_n2826.n256 585
R982 w_80_n2826.n258 w_80_n2826.n257 585
R983 w_80_n2826.n78 w_80_n2826.n258 585
R984 w_80_n2826.n260 w_80_n2826.n259 585
R985 w_80_n2826.n76 w_80_n2826.n260 585
R986 w_80_n2826.n262 w_80_n2826.n261 585
R987 w_80_n2826.n74 w_80_n2826.n262 585
R988 w_80_n2826.n264 w_80_n2826.n263 585
R989 w_80_n2826.n72 w_80_n2826.n264 585
R990 w_80_n2826.n266 w_80_n2826.n265 585
R991 w_80_n2826.n70 w_80_n2826.n266 585
R992 w_80_n2826.n268 w_80_n2826.n267 585
R993 w_80_n2826.n68 w_80_n2826.n268 585
R994 w_80_n2826.n270 w_80_n2826.n269 585
R995 w_80_n2826.n66 w_80_n2826.n270 585
R996 w_80_n2826.n272 w_80_n2826.n271 585
R997 w_80_n2826.n64 w_80_n2826.n272 585
R998 w_80_n2826.n274 w_80_n2826.n273 585
R999 w_80_n2826.n62 w_80_n2826.n274 585
R1000 w_80_n2826.n276 w_80_n2826.n275 585
R1001 w_80_n2826.n60 w_80_n2826.n276 585
R1002 w_80_n2826.n278 w_80_n2826.n277 585
R1003 w_80_n2826.n58 w_80_n2826.n278 585
R1004 w_80_n2826.n280 w_80_n2826.n279 585
R1005 w_80_n2826.n56 w_80_n2826.n280 585
R1006 w_80_n2826.n282 w_80_n2826.n281 585
R1007 w_80_n2826.n54 w_80_n2826.n282 585
R1008 w_80_n2826.n284 w_80_n2826.n283 585
R1009 w_80_n2826.n52 w_80_n2826.n284 585
R1010 w_80_n2826.n286 w_80_n2826.n285 585
R1011 w_80_n2826.n50 w_80_n2826.n286 585
R1012 w_80_n2826.n288 w_80_n2826.n287 585
R1013 w_80_n2826.n48 w_80_n2826.n288 585
R1014 w_80_n2826.n290 w_80_n2826.n289 585
R1015 w_80_n2826.n46 w_80_n2826.n290 585
R1016 w_80_n2826.n292 w_80_n2826.n291 585
R1017 w_80_n2826.n44 w_80_n2826.n292 585
R1018 w_80_n2826.n294 w_80_n2826.n293 585
R1019 w_80_n2826.n42 w_80_n2826.n294 585
R1020 w_80_n2826.n296 w_80_n2826.n295 585
R1021 w_80_n2826.n40 w_80_n2826.n296 585
R1022 w_80_n2826.n298 w_80_n2826.n297 585
R1023 w_80_n2826.n38 w_80_n2826.n298 585
R1024 w_80_n2826.n300 w_80_n2826.n299 585
R1025 w_80_n2826.n36 w_80_n2826.n300 585
R1026 w_80_n2826.n302 w_80_n2826.n301 585
R1027 w_80_n2826.n34 w_80_n2826.n302 585
R1028 w_80_n2826.n304 w_80_n2826.n303 585
R1029 w_80_n2826.n32 w_80_n2826.n304 585
R1030 w_80_n2826.n306 w_80_n2826.n305 585
R1031 w_80_n2826.n30 w_80_n2826.n306 585
R1032 w_80_n2826.n308 w_80_n2826.n307 585
R1033 w_80_n2826.n28 w_80_n2826.n308 585
R1034 w_80_n2826.n310 w_80_n2826.n309 585
R1035 w_80_n2826.n26 w_80_n2826.n310 585
R1036 w_80_n2826.n312 w_80_n2826.n311 585
R1037 w_80_n2826.n24 w_80_n2826.n312 585
R1038 w_80_n2826.n314 w_80_n2826.n313 585
R1039 w_80_n2826.n22 w_80_n2826.n314 585
R1040 w_80_n2826.n316 w_80_n2826.n315 585
R1041 w_80_n2826.n20 w_80_n2826.n316 585
R1042 w_80_n2826.n318 w_80_n2826.n317 585
R1043 w_80_n2826.n18 w_80_n2826.n318 585
R1044 w_80_n2826.n320 w_80_n2826.n319 585
R1045 w_80_n2826.n16 w_80_n2826.n320 585
R1046 w_80_n2826.n322 w_80_n2826.n321 585
R1047 w_80_n2826.n14 w_80_n2826.n322 585
R1048 w_80_n2826.n324 w_80_n2826.n323 585
R1049 w_80_n2826.n11 w_80_n2826.n324 585
R1050 w_80_n2826.n326 w_80_n2826.n325 585
R1051 w_80_n2826.n9 w_80_n2826.n326 585
R1052 w_80_n2826.n328 w_80_n2826.n327 585
R1053 w_80_n2826.n7 w_80_n2826.n328 585
R1054 w_80_n2826.n330 w_80_n2826.n329 585
R1055 w_80_n2826.n5 w_80_n2826.n330 585
R1056 w_80_n2826.n331 w_80_n2826.n332 585
R1057 w_80_n2826.n3 w_80_n2826.n332 585
R1058 w_80_n2826.n2 w_80_n2826.n334 585
R1059 w_80_n2826.n333 w_80_n2826.n1 681.154
R1060 w_80_n2826.n2 w_80_n2826.n3 16.0005
R1061 w_80_n2826.n3 w_80_n2826.n5 16.0005
R1062 w_80_n2826.n5 w_80_n2826.n7 16.0005
R1063 w_80_n2826.n7 w_80_n2826.n9 16.0005
R1064 w_80_n2826.n9 w_80_n2826.n11 16.0005
R1065 w_80_n2826.n11 w_80_n2826.n14 16.0005
R1066 w_80_n2826.n14 w_80_n2826.n16 16.0005
R1067 w_80_n2826.n16 w_80_n2826.n18 16.0005
R1068 w_80_n2826.n18 w_80_n2826.n20 16.0005
R1069 w_80_n2826.n20 w_80_n2826.n22 16.0005
R1070 w_80_n2826.n22 w_80_n2826.n24 16.0005
R1071 w_80_n2826.n24 w_80_n2826.n26 16.0005
R1072 w_80_n2826.n26 w_80_n2826.n28 16.0005
R1073 w_80_n2826.n28 w_80_n2826.n30 16.0005
R1074 w_80_n2826.n30 w_80_n2826.n32 16.0005
R1075 w_80_n2826.n32 w_80_n2826.n34 16.0005
R1076 w_80_n2826.n34 w_80_n2826.n36 16.0005
R1077 w_80_n2826.n36 w_80_n2826.n38 16.0005
R1078 w_80_n2826.n38 w_80_n2826.n40 16.0005
R1079 w_80_n2826.n40 w_80_n2826.n42 16.0005
R1080 w_80_n2826.n42 w_80_n2826.n44 16.0005
R1081 w_80_n2826.n44 w_80_n2826.n46 16.0005
R1082 w_80_n2826.n46 w_80_n2826.n48 16.0005
R1083 w_80_n2826.n48 w_80_n2826.n50 16.0005
R1084 w_80_n2826.n50 w_80_n2826.n52 16.0005
R1085 w_80_n2826.n52 w_80_n2826.n54 16.0005
R1086 w_80_n2826.n54 w_80_n2826.n56 16.0005
R1087 w_80_n2826.n56 w_80_n2826.n58 16.0005
R1088 w_80_n2826.n58 w_80_n2826.n60 16.0005
R1089 w_80_n2826.n60 w_80_n2826.n62 16.0005
R1090 w_80_n2826.n62 w_80_n2826.n64 16.0005
R1091 w_80_n2826.n64 w_80_n2826.n66 16.0005
R1092 w_80_n2826.n66 w_80_n2826.n68 16.0005
R1093 w_80_n2826.n68 w_80_n2826.n70 16.0005
R1094 w_80_n2826.n70 w_80_n2826.n72 16.0005
R1095 w_80_n2826.n72 w_80_n2826.n74 16.0005
R1096 w_80_n2826.n74 w_80_n2826.n76 16.0005
R1097 w_80_n2826.n76 w_80_n2826.n78 16.0005
R1098 w_80_n2826.n78 w_80_n2826.n80 16.0005
R1099 w_80_n2826.n80 w_80_n2826.n82 16.0005
R1100 w_80_n2826.n82 w_80_n2826.n84 16.0005
R1101 w_80_n2826.n84 w_80_n2826.n87 16.0005
R1102 w_80_n2826.n87 w_80_n2826.n89 16.0005
R1103 w_80_n2826.n89 w_80_n2826.n91 16.0005
R1104 w_80_n2826.n91 w_80_n2826.n93 16.0005
R1105 w_80_n2826.n93 w_80_n2826.n95 16.0005
R1106 w_80_n2826.n95 w_80_n2826.n97 16.0005
R1107 w_80_n2826.n97 w_80_n2826.n99 16.0005
R1108 w_80_n2826.n99 w_80_n2826.n101 16.0005
R1109 w_80_n2826.n101 w_80_n2826.n103 16.0005
R1110 w_80_n2826.n103 w_80_n2826.n105 16.0005
R1111 w_80_n2826.n105 w_80_n2826.n107 16.0005
R1112 w_80_n2826.n107 w_80_n2826.n109 16.0005
R1113 w_80_n2826.n109 w_80_n2826.n111 16.0005
R1114 w_80_n2826.n111 w_80_n2826.n113 16.0005
R1115 w_80_n2826.n113 w_80_n2826.n115 16.0005
R1116 w_80_n2826.n115 w_80_n2826.n117 16.0005
R1117 w_80_n2826.n117 w_80_n2826.n119 16.0005
R1118 w_80_n2826.n119 w_80_n2826.n121 16.0005
R1119 w_80_n2826.n121 w_80_n2826.n123 16.0005
R1120 w_80_n2826.n123 w_80_n2826.n125 16.0005
R1121 w_80_n2826.n125 w_80_n2826.n127 16.0005
R1122 w_80_n2826.n127 w_80_n2826.n129 16.0005
R1123 w_80_n2826.n129 w_80_n2826.n131 16.0005
R1124 w_80_n2826.n131 w_80_n2826.n133 16.0005
R1125 w_80_n2826.n133 w_80_n2826.n135 16.0005
R1126 w_80_n2826.n135 w_80_n2826.n137 16.0005
R1127 w_80_n2826.n137 w_80_n2826.n139 16.0005
R1128 w_80_n2826.n139 w_80_n2826.n141 16.0005
R1129 w_80_n2826.n141 w_80_n2826.n143 16.0005
R1130 w_80_n2826.n143 w_80_n2826.n145 16.0005
R1131 w_80_n2826.n145 w_80_n2826.n147 16.0005
R1132 w_80_n2826.n147 w_80_n2826.n149 16.0005
R1133 w_80_n2826.n149 w_80_n2826.n151 16.0005
R1134 w_80_n2826.n151 w_80_n2826.n153 16.0005
R1135 w_80_n2826.n153 w_80_n2826.n155 16.0005
R1136 w_80_n2826.n155 w_80_n2826.n157 16.0005
R1137 w_80_n2826.n157 w_80_n2826.n160 16.0005
R1138 w_80_n2826.n160 w_80_n2826.n162 16.0005
R1139 w_80_n2826.n162 w_80_n2826.n164 16.0005
R1140 w_80_n2826.n164 w_80_n2826.n166 16.0005
R1141 w_80_n2826.n166 w_80_n2826.n168 16.0005
R1142 w_80_n2826.n334 w_80_n2826.n333 74.7856
R1143 w_80_n2826.n334 w_80_n2826.n332 191
R1144 w_80_n2826.n332 w_80_n2826.n330 191
R1145 w_80_n2826.n330 w_80_n2826.n328 191
R1146 w_80_n2826.n328 w_80_n2826.n326 191
R1147 w_80_n2826.n326 w_80_n2826.n324 191
R1148 w_80_n2826.n324 w_80_n2826.n322 191
R1149 w_80_n2826.n322 w_80_n2826.n320 191
R1150 w_80_n2826.n320 w_80_n2826.n318 191
R1151 w_80_n2826.n318 w_80_n2826.n316 191
R1152 w_80_n2826.n316 w_80_n2826.n314 191
R1153 w_80_n2826.n314 w_80_n2826.n312 191
R1154 w_80_n2826.n312 w_80_n2826.n310 191
R1155 w_80_n2826.n310 w_80_n2826.n308 191
R1156 w_80_n2826.n308 w_80_n2826.n306 191
R1157 w_80_n2826.n306 w_80_n2826.n304 191
R1158 w_80_n2826.n304 w_80_n2826.n302 191
R1159 w_80_n2826.n302 w_80_n2826.n300 191
R1160 w_80_n2826.n300 w_80_n2826.n298 191
R1161 w_80_n2826.n298 w_80_n2826.n296 191
R1162 w_80_n2826.n296 w_80_n2826.n294 191
R1163 w_80_n2826.n294 w_80_n2826.n292 191
R1164 w_80_n2826.n292 w_80_n2826.n290 191
R1165 w_80_n2826.n290 w_80_n2826.n288 191
R1166 w_80_n2826.n288 w_80_n2826.n286 191
R1167 w_80_n2826.n286 w_80_n2826.n284 191
R1168 w_80_n2826.n284 w_80_n2826.n282 191
R1169 w_80_n2826.n282 w_80_n2826.n280 191
R1170 w_80_n2826.n280 w_80_n2826.n278 191
R1171 w_80_n2826.n278 w_80_n2826.n276 191
R1172 w_80_n2826.n276 w_80_n2826.n274 191
R1173 w_80_n2826.n274 w_80_n2826.n272 191
R1174 w_80_n2826.n272 w_80_n2826.n270 191
R1175 w_80_n2826.n270 w_80_n2826.n268 191
R1176 w_80_n2826.n268 w_80_n2826.n266 191
R1177 w_80_n2826.n266 w_80_n2826.n264 191
R1178 w_80_n2826.n264 w_80_n2826.n262 191
R1179 w_80_n2826.n262 w_80_n2826.n260 191
R1180 w_80_n2826.n260 w_80_n2826.n258 191
R1181 w_80_n2826.n258 w_80_n2826.n256 191
R1182 w_80_n2826.n256 w_80_n2826.n254 191
R1183 w_80_n2826.n254 w_80_n2826.n252 191
R1184 w_80_n2826.n252 w_80_n2826.n250 191
R1185 w_80_n2826.n250 w_80_n2826.n248 191
R1186 w_80_n2826.n248 w_80_n2826.n246 191
R1187 w_80_n2826.n246 w_80_n2826.n244 191
R1188 w_80_n2826.n244 w_80_n2826.n242 191
R1189 w_80_n2826.n242 w_80_n2826.n240 191
R1190 w_80_n2826.n240 w_80_n2826.n238 191
R1191 w_80_n2826.n238 w_80_n2826.n236 191
R1192 w_80_n2826.n236 w_80_n2826.n234 191
R1193 w_80_n2826.n234 w_80_n2826.n232 191
R1194 w_80_n2826.n232 w_80_n2826.n230 191
R1195 w_80_n2826.n230 w_80_n2826.n228 191
R1196 w_80_n2826.n228 w_80_n2826.n226 191
R1197 w_80_n2826.n226 w_80_n2826.n224 191
R1198 w_80_n2826.n224 w_80_n2826.n222 191
R1199 w_80_n2826.n222 w_80_n2826.n220 191
R1200 w_80_n2826.n220 w_80_n2826.n218 191
R1201 w_80_n2826.n218 w_80_n2826.n216 191
R1202 w_80_n2826.n216 w_80_n2826.n214 191
R1203 w_80_n2826.n214 w_80_n2826.n212 191
R1204 w_80_n2826.n212 w_80_n2826.n210 191
R1205 w_80_n2826.n210 w_80_n2826.n208 191
R1206 w_80_n2826.n208 w_80_n2826.n206 191
R1207 w_80_n2826.n206 w_80_n2826.n204 191
R1208 w_80_n2826.n204 w_80_n2826.n202 191
R1209 w_80_n2826.n202 w_80_n2826.n200 191
R1210 w_80_n2826.n200 w_80_n2826.n198 191
R1211 w_80_n2826.n198 w_80_n2826.n196 191
R1212 w_80_n2826.n196 w_80_n2826.n194 191
R1213 w_80_n2826.n194 w_80_n2826.n192 191
R1214 w_80_n2826.n192 w_80_n2826.n190 191
R1215 w_80_n2826.n190 w_80_n2826.n188 191
R1216 w_80_n2826.n188 w_80_n2826.n186 191
R1217 w_80_n2826.n186 w_80_n2826.n184 191
R1218 w_80_n2826.n184 w_80_n2826.n182 191
R1219 w_80_n2826.n182 w_80_n2826.n180 191
R1220 w_80_n2826.n180 w_80_n2826.n178 191
R1221 w_80_n2826.n178 w_80_n2826.n176 191
R1222 w_80_n2826.n176 w_80_n2826.n174 191
R1223 w_80_n2826.n174 w_80_n2826.n172 191
R1224 w_80_n2826.n172 w_80_n2826.n170 191
R1225 w_80_n2826.n169 w_80_n2826.n0 681.154
R1226 w_80_n2826.n333 w_80_n2826.n331 414.255
R1227 w_80_n2826.n331 w_80_n2826.t2 119.782
R1228 w_80_n2826.n329 w_80_n2826.t2 13.3096
R1229 w_80_n2826.n329 w_80_n2826.n327 133.091
R1230 w_80_n2826.n327 w_80_n2826.n325 133.091
R1231 w_80_n2826.n325 w_80_n2826.n323 133.091
R1232 w_80_n2826.n323 w_80_n2826.n321 133.091
R1233 w_80_n2826.n321 w_80_n2826.n319 133.091
R1234 w_80_n2826.n319 w_80_n2826.n317 133.091
R1235 w_80_n2826.n317 w_80_n2826.t4 13.3096
R1236 w_80_n2826.t4 w_80_n2826.n315 119.782
R1237 w_80_n2826.n315 w_80_n2826.n313 133.091
R1238 w_80_n2826.n313 w_80_n2826.n311 133.091
R1239 w_80_n2826.n311 w_80_n2826.n309 133.091
R1240 w_80_n2826.n309 w_80_n2826.n307 133.091
R1241 w_80_n2826.n307 w_80_n2826.n305 133.091
R1242 w_80_n2826.n305 w_80_n2826.t6 39.9279
R1243 w_80_n2826.t6 w_80_n2826.n303 93.1644
R1244 w_80_n2826.n303 w_80_n2826.n301 133.091
R1245 w_80_n2826.n301 w_80_n2826.n299 133.091
R1246 w_80_n2826.n299 w_80_n2826.n297 133.091
R1247 w_80_n2826.n297 w_80_n2826.n295 133.091
R1248 w_80_n2826.n295 w_80_n2826.n293 133.091
R1249 w_80_n2826.n293 w_80_n2826.t0 66.5462
R1250 w_80_n2826.n291 w_80_n2826.t0 66.5462
R1251 w_80_n2826.n291 w_80_n2826.n289 133.091
R1252 w_80_n2826.n289 w_80_n2826.n287 133.091
R1253 w_80_n2826.n287 w_80_n2826.n285 133.091
R1254 w_80_n2826.n285 w_80_n2826.n283 133.091
R1255 w_80_n2826.n283 w_80_n2826.n281 133.091
R1256 w_80_n2826.n281 w_80_n2826.t8 93.1644
R1257 w_80_n2826.n279 w_80_n2826.t8 39.9279
R1258 w_80_n2826.n279 w_80_n2826.n277 133.091
R1259 w_80_n2826.n277 w_80_n2826.n275 133.091
R1260 w_80_n2826.n275 w_80_n2826.n273 133.091
R1261 w_80_n2826.n273 w_80_n2826.n271 133.091
R1262 w_80_n2826.n271 w_80_n2826.n269 133.091
R1263 w_80_n2826.n269 w_80_n2826.n267 133.091
R1264 w_80_n2826.n267 w_80_n2826.n265 133.091
R1265 w_80_n2826.n265 w_80_n2826.n263 133.091
R1266 w_80_n2826.n263 w_80_n2826.n261 133.091
R1267 w_80_n2826.n261 w_80_n2826.n259 133.091
R1268 w_80_n2826.n259 w_80_n2826.t10 119.782
R1269 w_80_n2826.n257 w_80_n2826.t10 13.3096
R1270 w_80_n2826.n257 w_80_n2826.n255 133.091
R1271 w_80_n2826.n255 w_80_n2826.n253 133.091
R1272 w_80_n2826.n253 w_80_n2826.n251 133.091
R1273 w_80_n2826.n251 w_80_n2826.n249 133.091
R1274 w_80_n2826.n249 w_80_n2826.n247 133.091
R1275 w_80_n2826.n247 w_80_n2826.n245 133.091
R1276 w_80_n2826.n245 w_80_n2826.t12 13.3096
R1277 w_80_n2826.t12 w_80_n2826.n243 119.782
R1278 w_80_n2826.n243 w_80_n2826.n241 133.091
R1279 w_80_n2826.n241 w_80_n2826.n239 133.091
R1280 w_80_n2826.n239 w_80_n2826.n237 133.091
R1281 w_80_n2826.n237 w_80_n2826.n235 133.091
R1282 w_80_n2826.n235 w_80_n2826.n233 133.091
R1283 w_80_n2826.n233 w_80_n2826.t14 39.9279
R1284 w_80_n2826.t14 w_80_n2826.n231 93.1644
R1285 w_80_n2826.n231 w_80_n2826.n229 133.091
R1286 w_80_n2826.n229 w_80_n2826.n227 133.091
R1287 w_80_n2826.n227 w_80_n2826.n225 133.091
R1288 w_80_n2826.n225 w_80_n2826.n223 133.091
R1289 w_80_n2826.n223 w_80_n2826.n221 133.091
R1290 w_80_n2826.n221 w_80_n2826.t16 66.5462
R1291 w_80_n2826.n219 w_80_n2826.t16 66.5462
R1292 w_80_n2826.n219 w_80_n2826.n217 133.091
R1293 w_80_n2826.n217 w_80_n2826.n215 133.091
R1294 w_80_n2826.n215 w_80_n2826.n213 133.091
R1295 w_80_n2826.n213 w_80_n2826.n211 133.091
R1296 w_80_n2826.n211 w_80_n2826.n209 133.091
R1297 w_80_n2826.n209 w_80_n2826.t18 93.1644
R1298 w_80_n2826.n207 w_80_n2826.t18 39.9279
R1299 w_80_n2826.n207 w_80_n2826.n205 133.091
R1300 w_80_n2826.n205 w_80_n2826.n203 133.091
R1301 w_80_n2826.n203 w_80_n2826.n201 133.091
R1302 w_80_n2826.n201 w_80_n2826.n199 133.091
R1303 w_80_n2826.n199 w_80_n2826.n197 133.091
R1304 w_80_n2826.n197 w_80_n2826.n195 133.091
R1305 w_80_n2826.n195 w_80_n2826.n193 133.091
R1306 w_80_n2826.n193 w_80_n2826.n191 133.091
R1307 w_80_n2826.n191 w_80_n2826.n189 133.091
R1308 w_80_n2826.n189 w_80_n2826.n187 133.091
R1309 w_80_n2826.n187 w_80_n2826.t20 119.782
R1310 w_80_n2826.n185 w_80_n2826.t20 13.3096
R1311 w_80_n2826.n185 w_80_n2826.n183 133.091
R1312 w_80_n2826.n183 w_80_n2826.n181 133.091
R1313 w_80_n2826.n181 w_80_n2826.n179 133.091
R1314 w_80_n2826.n179 w_80_n2826.n177 133.091
R1315 w_80_n2826.n177 w_80_n2826.n175 133.091
R1316 w_80_n2826.n175 w_80_n2826.n173 133.091
R1317 w_80_n2826.n173 w_80_n2826.t22 13.3096
R1318 w_80_n2826.t22 w_80_n2826.n171 119.782
R1319 w_80_n2826.n169 w_80_n2826.n171 414.255
R1320 w_80_n2826.n159 w_80_n2826.n158 14.5144
R1321 w_80_n2826.n158 w_80_n2826.t21 7.838
R1322 w_80_n2826.n158 w_80_n2826.t23 7.838
R1323 w_80_n2826.n86 w_80_n2826.n85 14.5144
R1324 w_80_n2826.n85 w_80_n2826.t11 7.838
R1325 w_80_n2826.n85 w_80_n2826.t13 7.838
R1326 w_80_n2826.n13 w_80_n2826.n12 14.5144
R1327 w_80_n2826.n12 w_80_n2826.t3 7.838
R1328 w_80_n2826.n12 w_80_n2826.t5 7.838
C0 vg4 vcasc 1.39773f
C1 vdd vgu 3.46931f
C2 vg4 pbias 0.05589f
C3 vgu vg16 0.32209f
C4 vcasc vgu 0.77385f
C5 vg4 vgu 3.25322f
C6 vdd vg16 1.88619f
C7 pbias vgu 0.895f
C8 vdd vcasc 3.86134f
C9 vdd vg4 2.82221f
C10 vdd pbias 2.83165f
C11 vcasc vg16 1.25426f
C12 vg4 vg16 2.47288f
C13 pbias vg16 0.18939f
C14 pbias 0 0.43807f
C15 vg16 0 1.67785f
C16 vgu 0 5.68451f
C17 vg4 0 2.09356f
C18 vcasc 0 1.27682f
C19 vdd 0 71.09974f
C20 vdd.t15 0 0.18477f
C21 vdd.n0 0 0.02822f
C22 vdd.n3 0 0.01795f
C23 vdd.n71 0 0.11659f
C24 vdd.t5 0 0.05471f
C25 vdd.t3 0 0.05471f
C26 vdd.n72 0 0.17252f
C27 vdd.n131 0 0.09624f
C28 vdd.t10 0 0.38123f
C29 vdd.n132 0 0.08164f
C30 vdd.t13 0 0.17948f
C31 vdd.n146 0 0.22993f
C32 vdd.n148 0 0.08206f
C33 vdd.n150 0 0.14921f
C34 vdd.n152 0 0.14921f
C35 vdd.n154 0 0.14921f
C36 vdd.n156 0 0.14921f
C37 vdd.n158 0 0.08206f
C38 vdd.n160 0 0.14175f
C39 vdd.n162 0 0.14921f
C40 vdd.n164 0 0.14921f
C41 vdd.n166 0 0.14921f
C42 vdd.n168 0 0.14921f
C43 vdd.n170 0 0.09698f
C44 vdd.n172 0 0.12683f
C45 vdd.n174 0 0.14921f
C46 vdd.n176 0 0.14921f
C47 vdd.n178 0 0.14921f
C48 vdd.n180 0 0.11191f
C49 vdd.n182 0 0.11191f
C50 vdd.n184 0 0.14921f
C51 vdd.n186 0 0.14921f
C52 vdd.n188 0 0.14921f
C53 vdd.n190 0 0.14921f
C54 vdd.n192 0 0.14921f
C55 vdd.n194 0 0.14921f
C56 vdd.n196 0 0.14921f
C57 vdd.n198 0 0.12683f
C58 vdd.n200 0 0.09698f
C59 vdd.n202 0 0.14921f
C60 vdd.n204 0 0.14921f
C61 vdd.n206 0 0.14921f
C62 vdd.n208 0 0.14175f
C63 vdd.n210 0 0.08206f
C64 vdd.n212 0 0.14921f
C65 vdd.n214 0 0.14921f
C66 vdd.n216 0 0.14921f
C67 vdd.n218 0 0.14921f
C68 vdd.n220 0 0.14921f
C69 vdd.n222 0 0.08206f
C70 vdd.n224 0 0.14175f
C71 vdd.n226 0 0.14921f
C72 vdd.n228 0 0.14921f
C73 vdd.n230 0 0.14921f
C74 vdd.n232 0 0.09698f
C75 vdd.n234 0 0.12683f
C76 vdd.n236 0 0.14921f
C77 vdd.n238 0 0.14921f
C78 vdd.n240 0 0.14921f
C79 vdd.n242 0 0.14921f
C80 vdd.n244 0 0.14921f
C81 vdd.n246 0 0.14921f
C82 vdd.n248 0 0.14921f
C83 vdd.n250 0 0.11191f
C84 vdd.n252 0 0.11191f
C85 vdd.n254 0 0.14921f
C86 vdd.n256 0 0.14921f
C87 vdd.n258 0 0.14921f
C88 vdd.n260 0 0.12683f
C89 vdd.n262 0 0.09698f
C90 vdd.n264 0 0.14921f
C91 vdd.n266 0 0.14921f
C92 vdd.n268 0 0.14921f
C93 vdd.n270 0 0.14921f
C94 vdd.n272 0 0.14175f
C95 vdd.n274 0 0.08206f
C96 vdd.n276 0 0.14921f
C97 vdd.n278 0 0.14921f
C98 vdd.n280 0 0.14921f
C99 vdd.n282 0 0.14921f
C100 vdd.n284 0 0.08206f
C101 vdd.n286 0 0.14175f
C102 vdd.n288 0 0.23745f
C103 vdd.n291 0 0.48657f
C104 vdd.n294 0 0.14921f
C105 vdd.n297 0 0.14921f
C106 vdd.n300 0 0.14921f
C107 vdd.n303 0 0.14921f
C108 vdd.n306 0 0.14921f
C109 vdd.n309 0 0.14921f
C110 vdd.t16 0 0.14921f
C111 vdd.n314 0 0.14921f
C112 vdd.n317 0 0.14921f
C113 vdd.n320 0 0.14921f
C114 vdd.n323 0 0.14921f
C115 vdd.n326 0 0.14921f
C116 vdd.n329 0 0.14921f
C117 vdd.n332 0 0.14921f
C118 vdd.n335 0 0.14921f
C119 vdd.n338 0 0.47f
C120 vdd.n339 0 0.01057f
C121 vdd.n341 0 0.02703f
C122 vdd.n342 0 0.12347f
C123 vdd.n358 0 0.01749f
C124 vdd.t17 0 0.09154f
C125 vdd.t18 0 0.42691f
C126 vdd.t0 0 0.0746f
C127 vdd.t6 0 0.0746f
C128 vdd.t19 0 0.0746f
C129 vdd.t20 0 0.0746f
C130 vdd.t4 0 0.0746f
C131 vdd.t2 0 0.0746f
C132 vdd.t21 0 0.0746f
C133 vdd.t22 0 0.0746f
C134 vdd.t8 0 0.0746f
C135 vdd.t11 0 0.0746f
C136 vdd.t14 0 0.0746f
C137 vdd.n359 0 0.47f
C138 vdd.n360 0 0.01119f
C139 vdd.n361 0 0.21774f
C140 vdd.n362 0 0.11659f
C141 vdd.t9 0 0.05471f
C142 vdd.t12 0 0.05471f
C143 vdd.n363 0 0.17004f
C144 vdd.n364 0 0.11659f
C145 vdd.t1 0 0.05471f
C146 vdd.t7 0 0.05471f
C147 vg4.t1 0 0.30723f
C148 vg4.n0 0 0.86507f
C149 vg4.n1 0 2.32122f
C150 vg4.t0 0 2.14667f
C151 vg4.n2 0 2.2456f
C152 vg4.t3 0 2.14667f
C153 vg4.t2 0 0.30723f
C154 vgu.t0 0 1.0533f
C155 vgu.n0 0 2.92537f
C156 vgu.t1 0 0.98531f
C157 vgu.n1 0 2.44463f
C158 vgu.t2 0 1.64544f
C159 vgu.t3 0 1.67212f
C160 vgu.n2 0 0.63105f
C161 vg16.t1 0 0.28055f
C162 vg16.n0 0 0.78539f
C163 vg16.n1 0 2.72313f
C164 vg16.t0 0 1.95957f
C165 vg16.t2 0 0.28055f
C166 a_200_n2280.t0 0 0.87678f
C167 a_200_n2280.t1 0 0.64562f
C168 a_1860_600.t0 0 0.66985f
C169 a_1860_600.t1 0 0.66985f
C170 a_420_n2480.t1 0 0.04472f
C171 a_420_n2480.n0 0 0.14791f
C172 a_420_n2480.t0 0 0.31099f
C173 a_420_n2480.n1 0 0.17114f
C174 a_420_n2480.t9 0 0.3111f
C175 a_420_n2480.n2 0 0.26548f
C176 a_420_n2480.t8 0 0.19647f
C177 a_420_n2480.n3 0 0.14791f
C178 a_420_n2480.t5 0 0.04472f
C179 a_420_n2480.t3 0 0.04472f
C180 a_420_n2480.n4 0 0.17156f
C181 a_420_n2480.t2 0 0.31104f
C182 a_420_n2480.n5 0 0.0843f
C183 a_420_n2480.t4 0 0.311f
C184 a_420_n2480.t6 0 0.31099f
C185 a_420_n2480.n6 0 0.08719f
C186 a_420_n2480.n7 0 0.09667f
C187 a_420_n2480.t7 0 0.04472f
C188 a_2780_600.t0 0 1.90687f
C189 a_2780_600.t1 0 1.26515f
C190 a_4440_600.t0 0 0.66853f
C191 a_4440_600.t1 0 0.66853f
C192 a_4020_n2480.t1 0 0.03563f
C193 a_4020_n2480.n0 0 0.11786f
C194 a_4020_n2480.n1 0 0.28359f
C195 a_4020_n2480.t8 0 0.15655f
C196 a_4020_n2480.t0 0 0.24781f
C197 a_4020_n2480.n2 0 0.13637f
C198 a_4020_n2480.t9 0 0.2479f
C199 a_4020_n2480.n3 0 0.11786f
C200 a_4020_n2480.t5 0 0.03563f
C201 a_4020_n2480.t7 0 0.03563f
C202 a_4020_n2480.n4 0 0.13828f
C203 a_4020_n2480.t6 0 0.24785f
C204 a_4020_n2480.t4 0 0.24781f
C205 a_4020_n2480.n5 0 0.07004f
C206 a_4020_n2480.t2 0 0.24781f
C207 a_4020_n2480.n6 0 0.07004f
C208 a_4020_n2480.t3 0 0.03563f
C209 a_5780_600.t0 0 0.68017f
C210 a_5780_600.t1 0 0.68017f
C211 a_7020_600.t0 0 0.68961f
C212 a_7020_600.t1 0 0.68961f
C213 a_7400_n2280.t0 0 0.14153f
C214 a_7400_n2280.t2 0 0.28765f
C215 a_7400_n2280.n0 0 0.65648f
C216 a_7400_n2280.t3 0 0.48732f
C217 a_7400_n2280.t1 0 0.48715f
C218 a_7400_n2280.n1 0 0.33644f
.ends
