* NGSPICE file created from raildrv.ext - technology: sky130A

.subckt raildrv
X0 a_n3800_3834.t3 a_n3800_2594.t4 VSUB.t5 VSUB.t4 sky130_fd_pr__nfet_g5v0d10v5 ad=4.4 pd=10.2 as=2.2 ps=5.1 w=4 l=2
X1 a_n3800_1974.t2 pbias vdd.t2 vdd.t0 sky130_fd_pr__pfet_g5v0d10v5 ad=8.8 pd=17.1 as=8.8 ps=17.1 w=16 l=4
X2 VSUB.t3 a_n3800_3834.t4 ve.t2 VSUB.t2 sky130_fd_pr__nfet_g5v0d10v5 ad=4.4 pd=9.1 as=8.8 ps=18.2 w=8 l=1
X3 a_n3800_3834.t2 nd055 a_n3800_1974.t4 vdd.t0 sky130_fd_pr__pfet_g5v0d10v5 ad=8.8 pd=17.1 as=8.8 ps=17.1 w=16 l=2
X4 a_n3800_2594.t0 ve.t4 a_n3800_1974.t0 vdd.t0 sky130_fd_pr__pfet_g5v0d10v5 ad=8.8 pd=17.1 as=8.8 ps=17.1 w=16 l=2
X5 VSUB.t6 a_n3800_2594.t2 a_n3800_2594.t3 VSUB.t4 sky130_fd_pr__nfet_g5v0d10v5 ad=2.2 pd=5.1 as=4.4 ps=10.2 w=4 l=2
X6 ve.t1 a_n3800_3834.t5 VSUB.t1 VSUB.t0 sky130_fd_pr__nfet_g5v0d10v5 ad=8.8 pd=18.2 as=4.4 ps=9.1 w=8 l=1
X7 vdd.t1 pbias ve.t0 vdd.t0 sky130_fd_pr__pfet_g5v0d10v5 ad=8.8 pd=17.1 as=17.6 ps=34.2 w=16 l=2.67
X8 a_n3800_1974.t1 ve.t5 a_n3800_2594.t1 vdd.t0 sky130_fd_pr__pfet_g5v0d10v5 ad=8.8 pd=17.1 as=8.8 ps=17.1 w=16 l=2
X9 a_n3800_1974.t3 nd055 a_n3800_3834.t1 vdd.t0 sky130_fd_pr__pfet_g5v0d10v5 ad=17.6 pd=34.2 as=8.8 ps=17.1 w=16 l=2
X10 ve.t3 a_n3800_3834.t0 sky130_fd_pr__cap_mim_m3_1 l=58 w=17.3
R0 a_n3800_2594.t3 a_n3800_2594.n2 49.2892
R1 a_n3800_2594.n2 a_n3800_2594.t2 229.931
R2 a_n3800_2594.n2 a_n3800_2594.n1 0.84425
R3 a_n3800_2594.n1 a_n3800_2594.t4 229.931
R4 a_n3800_2594.n1 a_n3800_2594.n0 28.8967
R5 a_n3800_2594.n0 a_n3800_2594.t0 6.56613
R6 a_n3800_2594.n0 a_n3800_2594.t1 6.56613
R7 a_n3800_1974.n0 a_n3800_1974.t2 6.56613
R8 a_n3800_1974.t0 a_n3800_1974.n0 6.56613
R9 a_n3800_1974.n0 a_n3800_1974.n1 28.0758
R10 a_n3800_1974.n1 a_n3800_1974.n2 26.2638
R11 a_n3800_1974.n2 a_n3800_1974.t1 6.56613
R12 a_n3800_1974.n2 a_n3800_1974.t4 6.56613
R13 a_n3800_1974.n1 a_n3800_1974.t3 34.6415
R14 a_n3800_3834.t3 a_n3800_3834.n3 49.3049
R15 a_n3800_3834.n3 a_n3800_3834.n1 3.74112
R16 a_n3800_3834.n1 a_n3800_3834.n2 0.838
R17 a_n3800_3834.n3 a_n3800_3834.t0 5.8938
R18 a_n3800_3834.n2 a_n3800_3834.t4 390.634
R19 a_n3800_3834.n2 a_n3800_3834.t5 391.164
R20 a_n3800_3834.n1 a_n3800_3834.n0 26.2337
R21 a_n3800_3834.n0 a_n3800_3834.t2 6.56613
R22 a_n3800_3834.n0 a_n3800_3834.t1 6.56613
R23 ve.n4 ve.t1 27.7775
R24 ve.n1 ve.n0 2.86925
R25 ve.n0 ve.n4 1.313
R26 ve.n3 ve.n2 0.1255
R27 ve.n2 ve.n1 5.30779
R28 ve.n3 ve.t5 375.26
R29 ve ve.n3 7.26112
R30 ve.n2 ve.t4 374.265
R31 ve.n1 ve.t0 35.3681
R32 ve.n4 ve.t3 18.6588
R33 ve.n0 ve.t2 27.7789
R34 vdd.n1 vdd.n2 185
R35 vdd.n3 vdd.n5 43.5754
R36 vdd.n4 vdd.n3 185
R37 vdd.n5 vdd.n1 70.7138
R38 vdd.n7 vdd.n6 185
R39 vdd.n10 vdd.n8 43.5754
R40 vdd.n9 vdd.n8 185
R41 vdd.n1 vdd.n10 70.7138
R42 vdd.n12 vdd.n11 185
R43 vdd.n15 vdd.n13 43.5754
R44 vdd.n14 vdd.n13 185
R45 vdd.n1 vdd.n15 70.7138
R46 vdd.n17 vdd.n16 185
R47 vdd.n18 vdd.n20 43.5754
R48 vdd.n19 vdd.n18 185
R49 vdd.n1 vdd.n20 70.7138
R50 vdd.n22 vdd.n21 185
R51 vdd.n23 vdd.n25 43.5754
R52 vdd.n24 vdd.n23 185
R53 vdd.n1 vdd.n25 70.7138
R54 vdd.n27 vdd.n26 185
R55 vdd.n28 vdd.n30 43.5754
R56 vdd.n29 vdd.n28 185
R57 vdd.n1 vdd.n30 70.7138
R58 vdd.n32 vdd.n31 185
R59 vdd.n33 vdd.n35 43.5754
R60 vdd.n34 vdd.n33 185
R61 vdd.n1 vdd.n35 70.7138
R62 vdd.n37 vdd.n36 185
R63 vdd.n38 vdd.n40 43.5754
R64 vdd.n39 vdd.n38 185
R65 vdd.n1 vdd.n40 70.7138
R66 vdd.n42 vdd.n41 185
R67 vdd.n43 vdd.n45 43.5754
R68 vdd.n44 vdd.n43 185
R69 vdd.n1 vdd.n45 70.7138
R70 vdd.n47 vdd.n46 185
R71 vdd.n48 vdd.n50 43.5754
R72 vdd.n49 vdd.n48 185
R73 vdd.n1 vdd.n50 70.7138
R74 vdd.n52 vdd.n51 185
R75 vdd.n53 vdd.n55 43.5754
R76 vdd.n54 vdd.n53 185
R77 vdd.n1 vdd.n55 70.7138
R78 vdd.n57 vdd.n56 185
R79 vdd.n58 vdd.n60 43.5754
R80 vdd.n59 vdd.n58 185
R81 vdd.n1 vdd.n60 70.7138
R82 vdd.n62 vdd.n61 185
R83 vdd.n63 vdd.n65 43.5754
R84 vdd.n64 vdd.n63 185
R85 vdd.n1 vdd.n65 70.7138
R86 vdd.n67 vdd.n66 185
R87 vdd.n68 vdd.n70 43.5754
R88 vdd.n69 vdd.n68 185
R89 vdd.n1 vdd.n70 70.7138
R90 vdd.n72 vdd.n71 185
R91 vdd.n73 vdd.n75 43.5754
R92 vdd.n74 vdd.n73 185
R93 vdd.n1 vdd.n75 70.7138
R94 vdd.n77 vdd.n76 185
R95 vdd.n78 vdd.n80 43.5754
R96 vdd.n79 vdd.n78 185
R97 vdd.n1 vdd.n80 70.7138
R98 vdd.n82 vdd.n81 185
R99 vdd.n83 vdd.n85 43.5754
R100 vdd.n84 vdd.n83 185
R101 vdd.n1 vdd.n85 70.7138
R102 vdd.n87 vdd.n86 185
R103 vdd.n88 vdd.n90 43.5754
R104 vdd.n89 vdd.n88 185
R105 vdd.n1 vdd.n90 70.7138
R106 vdd.n92 vdd.n91 185
R107 vdd.n93 vdd.n95 43.5754
R108 vdd.n94 vdd.n93 185
R109 vdd.n1 vdd.n95 70.7138
R110 vdd.n97 vdd.n96 185
R111 vdd.n98 vdd.n100 43.5754
R112 vdd.n99 vdd.n98 185
R113 vdd.n1 vdd.n100 70.7138
R114 vdd.n102 vdd.n101 185
R115 vdd.n1 vdd.n103 70.7138
R116 vdd.n105 vdd.n104 185
R117 vdd.n249 vdd.n234 70.7138
R118 vdd.n147 vdd.n148 185
R119 vdd.n235 vdd.n149 43.5754
R120 vdd.n149 vdd.n150 185
R121 vdd.n249 vdd.n235 70.7138
R122 vdd.n151 vdd.n152 185
R123 vdd.n236 vdd.n153 43.5754
R124 vdd.n153 vdd.n154 185
R125 vdd.n249 vdd.n236 70.7138
R126 vdd.n155 vdd.n156 185
R127 vdd.n237 vdd.n157 43.5754
R128 vdd.n157 vdd.n158 185
R129 vdd.n249 vdd.n237 70.7138
R130 vdd.n159 vdd.n160 185
R131 vdd.n238 vdd.n161 43.5754
R132 vdd.n161 vdd.n162 185
R133 vdd.n249 vdd.n238 70.7138
R134 vdd.n163 vdd.n164 185
R135 vdd.n239 vdd.n165 43.5754
R136 vdd.n165 vdd.n166 185
R137 vdd.n249 vdd.n239 70.7138
R138 vdd.n167 vdd.n168 185
R139 vdd.n240 vdd.n169 43.5754
R140 vdd.n169 vdd.n170 185
R141 vdd.n249 vdd.n240 70.7138
R142 vdd.n171 vdd.n172 185
R143 vdd.n241 vdd.n173 43.5754
R144 vdd.n173 vdd.n174 185
R145 vdd.n249 vdd.n241 70.7138
R146 vdd.n175 vdd.n176 185
R147 vdd.n242 vdd.n177 43.5754
R148 vdd.n177 vdd.n178 185
R149 vdd.n249 vdd.n242 70.7138
R150 vdd.n179 vdd.n180 185
R151 vdd.n243 vdd.n181 43.5754
R152 vdd.n181 vdd.n182 185
R153 vdd.n249 vdd.n243 70.7138
R154 vdd.n183 vdd.n184 185
R155 vdd.n244 vdd.n185 43.5754
R156 vdd.n185 vdd.n186 185
R157 vdd.n249 vdd.n244 70.7138
R158 vdd.n187 vdd.n188 185
R159 vdd.n245 vdd.n189 104.573
R160 vdd.n249 vdd.n245 40.2146
R161 vdd.n246 vdd.n212 43.5754
R162 vdd.n212 vdd.n213 185
R163 vdd.n249 vdd.n246 70.7138
R164 vdd.n214 vdd.n215 185
R165 vdd.n247 vdd.n216 43.5754
R166 vdd.n216 vdd.n217 185
R167 vdd.n249 vdd.n247 70.7138
R168 vdd.n218 vdd.n219 185
R169 vdd.n248 vdd.n220 43.5754
R170 vdd.n220 vdd.n221 185
R171 vdd.n249 vdd.n248 70.7138
R172 vdd.n222 vdd.n223 185
R173 vdd.n224 vdd.n225 185
R174 vdd.n249 vdd.n233 59.3852
R175 vdd.n0 vdd.n1 34.2602
R176 vdd.n1 vdd.t0 550.17
R177 vdd.t0 vdd.n249 380.887
R178 vdd.n234 vdd.n147 43.5754
R179 vdd.n147 vdd.n149 114.001
R180 vdd.n235 vdd.n151 43.5754
R181 vdd.n151 vdd.n153 114.001
R182 vdd.n236 vdd.n155 43.5754
R183 vdd.n155 vdd.n157 114.001
R184 vdd.n237 vdd.n159 43.5754
R185 vdd.n159 vdd.n161 114.001
R186 vdd.n238 vdd.n163 43.5754
R187 vdd.n163 vdd.n165 114.001
R188 vdd.n239 vdd.n167 43.5754
R189 vdd.n167 vdd.n169 114.001
R190 vdd.n240 vdd.n171 43.5754
R191 vdd.n171 vdd.n173 114.001
R192 vdd.n241 vdd.n175 43.5754
R193 vdd.n175 vdd.n177 114.001
R194 vdd.n242 vdd.n179 43.5754
R195 vdd.n179 vdd.n181 114.001
R196 vdd.n243 vdd.n183 43.5754
R197 vdd.n183 vdd.n185 114.001
R198 vdd.n244 vdd.n187 43.5754
R199 vdd.n187 vdd.n189 114.001
R200 vdd.n245 vdd.n211 104.573
R201 vdd.n211 vdd.n212 114.001
R202 vdd.n246 vdd.n214 43.5754
R203 vdd.n214 vdd.n216 114.001
R204 vdd.n247 vdd.n218 43.5754
R205 vdd.n218 vdd.n220 114.001
R206 vdd.n248 vdd.n222 43.5754
R207 vdd.n222 vdd.n224 114.001
R208 vdd.n233 vdd.n224 47.8954
R209 vdd.n233 vdd.n227 225.948
R210 vdd.n227 vdd.n225 4.28224
R211 vdd.n228 vdd.n223 9.3005
R212 vdd.n229 vdd.n221 9.3005
R213 vdd.n230 vdd.n219 9.3005
R214 vdd.n231 vdd.n217 9.3005
R215 vdd.n232 vdd.n215 9.3005
R216 vdd.n226 vdd.n213 4.28224
R217 vdd.n211 vdd.n226 189.355
R218 vdd.n213 vdd.n215 16.0005
R219 vdd.n215 vdd.n217 16.0005
R220 vdd.n217 vdd.n219 16.0005
R221 vdd.n219 vdd.n221 16.0005
R222 vdd.n221 vdd.n223 16.0005
R223 vdd.n223 vdd.n225 16.0005
R224 vdd.n232 vdd.n226 2.68753
R225 vdd.n231 vdd.n232 0.15675
R226 vdd.n230 vdd.n231 0.15675
R227 vdd.n229 vdd.n230 0.15675
R228 vdd.n228 vdd.n229 0.15675
R229 vdd.n227 vdd.n228 2.68753
R230 vdd.n188 vdd.n191 4.28224
R231 vdd.n186 vdd.n192 9.3005
R232 vdd.n184 vdd.n193 9.3005
R233 vdd.n182 vdd.n194 9.3005
R234 vdd.n180 vdd.n195 9.3005
R235 vdd.n178 vdd.n196 9.3005
R236 vdd.n176 vdd.n197 9.3005
R237 vdd.n174 vdd.n198 9.3005
R238 vdd.n172 vdd.n199 9.3005
R239 vdd.n170 vdd.n200 9.3005
R240 vdd.n168 vdd.n201 9.3005
R241 vdd.n166 vdd.n202 9.3005
R242 vdd.n164 vdd.n203 9.3005
R243 vdd.n162 vdd.n204 9.3005
R244 vdd.n160 vdd.n205 9.3005
R245 vdd.n158 vdd.n206 9.3005
R246 vdd.n156 vdd.n207 9.3005
R247 vdd.n154 vdd.n208 9.3005
R248 vdd.n152 vdd.n209 9.3005
R249 vdd.n150 vdd.n210 9.3005
R250 vdd.n148 vdd.n190 4.28224
R251 vdd.n234 vdd.n190 232.929
R252 vdd.n148 vdd.n150 16.0005
R253 vdd.n150 vdd.n152 16.0005
R254 vdd.n152 vdd.n154 16.0005
R255 vdd.n154 vdd.n156 16.0005
R256 vdd.n156 vdd.n158 16.0005
R257 vdd.n158 vdd.n160 16.0005
R258 vdd.n160 vdd.n162 16.0005
R259 vdd.n162 vdd.n164 16.0005
R260 vdd.n164 vdd.n166 16.0005
R261 vdd.n166 vdd.n168 16.0005
R262 vdd.n168 vdd.n170 16.0005
R263 vdd.n170 vdd.n172 16.0005
R264 vdd.n172 vdd.n174 16.0005
R265 vdd.n174 vdd.n176 16.0005
R266 vdd.n176 vdd.n178 16.0005
R267 vdd.n178 vdd.n180 16.0005
R268 vdd.n180 vdd.n182 16.0005
R269 vdd.n182 vdd.n184 16.0005
R270 vdd.n184 vdd.n186 16.0005
R271 vdd.n186 vdd.n188 16.0005
R272 vdd.n191 vdd.n189 189.355
R273 vdd.n190 vdd.n210 2.68753
R274 vdd.n210 vdd.n209 0.15675
R275 vdd.n209 vdd.n208 0.15675
R276 vdd.n208 vdd.n207 0.15675
R277 vdd.n207 vdd.n206 0.15675
R278 vdd.n206 vdd.n205 0.15675
R279 vdd.n205 vdd.n204 0.15675
R280 vdd.n204 vdd.n203 0.15675
R281 vdd.n203 vdd.n202 0.15675
R282 vdd.n202 vdd.n201 0.15675
R283 vdd.n201 vdd.n200 0.15675
R284 vdd.n199 vdd.n200 0.15675
R285 vdd.n198 vdd.n199 0.15675
R286 vdd.n197 vdd.n198 0.15675
R287 vdd.n196 vdd.n197 0.15675
R288 vdd.n195 vdd.n196 0.15675
R289 vdd.n194 vdd.n195 0.15675
R290 vdd.n193 vdd.n194 0.15675
R291 vdd.n192 vdd.n193 0.15675
R292 vdd.n191 vdd.n192 2.68753
R293 vdd.n107 vdd.n4 4.28224
R294 vdd.n108 vdd.n7 9.3005
R295 vdd.n109 vdd.n9 9.3005
R296 vdd.n110 vdd.n12 9.3005
R297 vdd.n111 vdd.n14 9.3005
R298 vdd.n112 vdd.n17 9.3005
R299 vdd vdd.n19 9.3005
R300 vdd.n113 vdd.n22 9.3005
R301 vdd.n114 vdd.n24 9.3005
R302 vdd.n115 vdd.n27 9.3005
R303 vdd.n116 vdd.n29 9.3005
R304 vdd.n117 vdd.n32 9.3005
R305 vdd.n118 vdd.n34 9.3005
R306 vdd.n119 vdd.n37 9.3005
R307 vdd.n120 vdd.n39 9.3005
R308 vdd.n121 vdd.n42 9.3005
R309 vdd.n122 vdd.n44 9.3005
R310 vdd.n123 vdd.n47 9.3005
R311 vdd.n124 vdd.n49 9.3005
R312 vdd.n125 vdd.n52 9.3005
R313 vdd.n126 vdd.n54 9.3005
R314 vdd.n127 vdd.n57 9.3005
R315 vdd.n128 vdd.n59 9.3005
R316 vdd.n129 vdd.n62 9.3005
R317 vdd.n130 vdd.n64 9.3005
R318 vdd.n131 vdd.n67 9.3005
R319 vdd.n132 vdd.n69 9.3005
R320 vdd.n133 vdd.n72 9.3005
R321 vdd.n134 vdd.n74 9.3005
R322 vdd.n135 vdd.n77 9.3005
R323 vdd.n136 vdd.n79 9.3005
R324 vdd.n137 vdd.n82 9.3005
R325 vdd.n138 vdd.n84 9.3005
R326 vdd.n139 vdd.n87 9.3005
R327 vdd.n140 vdd.n89 9.3005
R328 vdd.n141 vdd.n92 9.3005
R329 vdd.n142 vdd.n94 9.3005
R330 vdd.n143 vdd.n97 9.3005
R331 vdd.n144 vdd.n99 9.3005
R332 vdd.n145 vdd.n102 9.3005
R333 vdd.n106 vdd.n105 4.28224
R334 vdd.n107 vdd.n2 189.355
R335 vdd.n4 vdd.n7 16.0005
R336 vdd.n7 vdd.n9 16.0005
R337 vdd.n9 vdd.n12 16.0005
R338 vdd.n12 vdd.n14 16.0005
R339 vdd.n14 vdd.n17 16.0005
R340 vdd.n17 vdd.n19 16.0005
R341 vdd.n19 vdd.n22 16.0005
R342 vdd.n22 vdd.n24 16.0005
R343 vdd.n24 vdd.n27 16.0005
R344 vdd.n27 vdd.n29 16.0005
R345 vdd.n29 vdd.n32 16.0005
R346 vdd.n32 vdd.n34 16.0005
R347 vdd.n34 vdd.n37 16.0005
R348 vdd.n37 vdd.n39 16.0005
R349 vdd.n39 vdd.n42 16.0005
R350 vdd.n42 vdd.n44 16.0005
R351 vdd.n44 vdd.n47 16.0005
R352 vdd.n47 vdd.n49 16.0005
R353 vdd.n49 vdd.n52 16.0005
R354 vdd.n52 vdd.n54 16.0005
R355 vdd.n54 vdd.n57 16.0005
R356 vdd.n57 vdd.n59 16.0005
R357 vdd.n59 vdd.n62 16.0005
R358 vdd.n62 vdd.n64 16.0005
R359 vdd.n64 vdd.n67 16.0005
R360 vdd.n67 vdd.n69 16.0005
R361 vdd.n69 vdd.n72 16.0005
R362 vdd.n72 vdd.n74 16.0005
R363 vdd.n74 vdd.n77 16.0005
R364 vdd.n77 vdd.n79 16.0005
R365 vdd.n79 vdd.n82 16.0005
R366 vdd.n82 vdd.n84 16.0005
R367 vdd.n84 vdd.n87 16.0005
R368 vdd.n87 vdd.n89 16.0005
R369 vdd.n89 vdd.n92 16.0005
R370 vdd.n92 vdd.n94 16.0005
R371 vdd.n94 vdd.n97 16.0005
R372 vdd.n97 vdd.n99 16.0005
R373 vdd.n99 vdd.n102 16.0005
R374 vdd.n102 vdd.n105 16.0005
R375 vdd.n106 vdd.n103 232.929
R376 vdd vdd.n113 0.0520625
R377 vdd.n113 vdd.n114 0.15675
R378 vdd.n114 vdd.n115 0.15675
R379 vdd.n115 vdd.n116 0.15675
R380 vdd.n116 vdd.n117 0.15675
R381 vdd.n117 vdd.n118 0.15675
R382 vdd.n118 vdd.n119 0.15675
R383 vdd.n119 vdd.n120 0.15675
R384 vdd.n120 vdd.n121 0.15675
R385 vdd.n121 vdd.n122 0.15675
R386 vdd.n122 vdd.n123 0.15675
R387 vdd.n123 vdd.n124 0.15675
R388 vdd.n124 vdd.n125 0.15675
R389 vdd.n125 vdd.n126 0.15675
R390 vdd.n126 vdd.n127 0.15675
R391 vdd.n127 vdd.n128 0.15675
R392 vdd.n128 vdd.n129 0.15675
R393 vdd.n129 vdd.n130 0.15675
R394 vdd.n130 vdd.n131 0.15675
R395 vdd.n131 vdd.n132 0.15675
R396 vdd.n132 vdd.n133 0.15675
R397 vdd.n133 vdd.n134 0.15675
R398 vdd.n134 vdd.n135 0.15675
R399 vdd.n135 vdd.n136 0.15675
R400 vdd.n136 vdd.n137 0.15675
R401 vdd.n137 vdd.n138 0.15675
R402 vdd.n138 vdd.n139 0.15675
R403 vdd.n139 vdd.n140 0.15675
R404 vdd.n140 vdd.n141 0.15675
R405 vdd.n141 vdd.n142 0.15675
R406 vdd.n142 vdd.n143 0.15675
R407 vdd.n143 vdd.n144 0.15675
R408 vdd.n144 vdd.n145 0.15675
R409 vdd.n145 vdd.n106 2.68753
R410 vdd.n108 vdd.n107 2.68753
R411 vdd.n109 vdd.n108 0.15675
R412 vdd.n110 vdd.n109 0.15675
R413 vdd.n111 vdd.n110 0.15675
R414 vdd.n112 vdd.n111 0.15675
R415 vdd vdd.n112 0.136437
R416 vdd vdd.n146 22.6825
R417 vdd.n146 vdd.t1 6.56613
R418 vdd.n146 vdd.t2 6.56613
R419 vdd.n2 vdd.n3 114.001
R420 vdd.n5 vdd.n6 43.5754
R421 vdd.n6 vdd.n8 114.001
R422 vdd.n11 vdd.n10 43.5754
R423 vdd.n11 vdd.n13 114.001
R424 vdd.n16 vdd.n15 43.5754
R425 vdd.n16 vdd.n18 114.001
R426 vdd.n20 vdd.n21 43.5754
R427 vdd.n21 vdd.n23 114.001
R428 vdd.n25 vdd.n26 43.5754
R429 vdd.n26 vdd.n28 114.001
R430 vdd.n30 vdd.n31 43.5754
R431 vdd.n31 vdd.n33 114.001
R432 vdd.n35 vdd.n36 43.5754
R433 vdd.n36 vdd.n38 114.001
R434 vdd.n40 vdd.n41 43.5754
R435 vdd.n41 vdd.n43 114.001
R436 vdd.n45 vdd.n46 43.5754
R437 vdd.n46 vdd.n48 114.001
R438 vdd.n50 vdd.n51 43.5754
R439 vdd.n51 vdd.n53 114.001
R440 vdd.n55 vdd.n56 43.5754
R441 vdd.n56 vdd.n58 114.001
R442 vdd.n60 vdd.n61 43.5754
R443 vdd.n61 vdd.n63 114.001
R444 vdd.n65 vdd.n66 43.5754
R445 vdd.n66 vdd.n68 114.001
R446 vdd.n70 vdd.n71 43.5754
R447 vdd.n71 vdd.n73 114.001
R448 vdd.n75 vdd.n76 43.5754
R449 vdd.n76 vdd.n78 114.001
R450 vdd.n80 vdd.n81 43.5754
R451 vdd.n81 vdd.n83 114.001
R452 vdd.n85 vdd.n86 43.5754
R453 vdd.n86 vdd.n88 114.001
R454 vdd.n90 vdd.n91 43.5754
R455 vdd.n91 vdd.n93 114.001
R456 vdd.n95 vdd.n96 43.5754
R457 vdd.n96 vdd.n98 114.001
R458 vdd.n100 vdd.n101 43.5754
R459 vdd.n101 vdd.n104 114.001
R460 vdd.n104 vdd.n103 43.5754
R461 VSUB.t3 VSUB.n0 7.838
R462 VSUB.n0 VSUB.t1 7.838
R463 VSUB.n168 VSUB.n0 14.582
R464 VSUB.n168 VSUB.n1 9.3005
R465 VSUB.n4 VSUB.n3 9.3005
R466 VSUB.n6 VSUB.n5 9.3005
R467 VSUB.n2 VSUB.n7 4.28224
R468 VSUB.n168 VSUB.n4 0.09425
R469 VSUB.n4 VSUB.n6 0.15675
R470 VSUB.n6 VSUB.n2 2.68753
R471 VSUB.n9 VSUB.n8 9.3005
R472 VSUB.n11 VSUB.n10 9.3005
R473 VSUB.n13 VSUB.n12 9.3005
R474 VSUB.n15 VSUB.n14 9.3005
R475 VSUB.n17 VSUB.n16 9.3005
R476 VSUB.n19 VSUB.n18 9.3005
R477 VSUB.n21 VSUB.n20 9.3005
R478 VSUB.n23 VSUB.n22 9.3005
R479 VSUB.n25 VSUB.n24 9.3005
R480 VSUB.n27 VSUB.n26 9.3005
R481 VSUB.n29 VSUB.n28 9.3005
R482 VSUB.n31 VSUB.n30 9.3005
R483 VSUB.n33 VSUB.n32 9.3005
R484 VSUB.n35 VSUB.n34 9.3005
R485 VSUB.n37 VSUB.n36 9.3005
R486 VSUB.n39 VSUB.n38 9.3005
R487 VSUB.n41 VSUB.n40 9.3005
R488 VSUB.n43 VSUB.n42 9.3005
R489 VSUB.n45 VSUB.n44 9.3005
R490 VSUB.n47 VSUB.n46 9.3005
R491 VSUB.n49 VSUB.n48 9.3005
R492 VSUB.n51 VSUB.n50 9.3005
R493 VSUB.n53 VSUB.n52 9.3005
R494 VSUB.n55 VSUB.n54 9.3005
R495 VSUB.n57 VSUB.n56 9.3005
R496 VSUB.n59 VSUB.n58 9.3005
R497 VSUB.n61 VSUB.n60 9.3005
R498 VSUB.n63 VSUB.n62 9.3005
R499 VSUB.n65 VSUB.n64 9.3005
R500 VSUB.n67 VSUB.n66 9.3005
R501 VSUB.n69 VSUB.n68 9.3005
R502 VSUB.n71 VSUB.n70 9.3005
R503 VSUB.n73 VSUB.n72 9.3005
R504 VSUB.n75 VSUB.n74 9.3005
R505 VSUB.n77 VSUB.n76 9.3005
R506 VSUB.n79 VSUB.n78 9.3005
R507 VSUB.n81 VSUB.n80 9.3005
R508 VSUB VSUB.n9 0.09425
R509 VSUB.n9 VSUB.n11 0.15675
R510 VSUB.n11 VSUB.n13 0.15675
R511 VSUB.n13 VSUB.n15 0.15675
R512 VSUB.n15 VSUB.n17 0.15675
R513 VSUB.n17 VSUB.n19 0.15675
R514 VSUB.n19 VSUB.n21 0.15675
R515 VSUB.n21 VSUB.n23 0.15675
R516 VSUB.n23 VSUB.n25 0.15675
R517 VSUB.n25 VSUB.n27 0.15675
R518 VSUB.n27 VSUB.n29 0.15675
R519 VSUB.n29 VSUB.n31 0.15675
R520 VSUB.n31 VSUB.n33 0.15675
R521 VSUB.n33 VSUB.n35 0.15675
R522 VSUB.n35 VSUB.n37 0.15675
R523 VSUB.n37 VSUB.n39 0.15675
R524 VSUB.n39 VSUB.n41 0.15675
R525 VSUB.n41 VSUB.n43 0.15675
R526 VSUB.n43 VSUB.n45 0.15675
R527 VSUB.n45 VSUB.n47 0.15675
R528 VSUB.n47 VSUB.n49 0.15675
R529 VSUB.n49 VSUB.n51 0.15675
R530 VSUB.n51 VSUB.n53 0.15675
R531 VSUB.n53 VSUB.n55 0.15675
R532 VSUB.n55 VSUB.n57 0.15675
R533 VSUB.n57 VSUB.n59 0.15675
R534 VSUB.n59 VSUB.n61 0.15675
R535 VSUB.n61 VSUB.n63 0.15675
R536 VSUB.n63 VSUB.n65 0.15675
R537 VSUB.n65 VSUB.n67 0.15675
R538 VSUB.n67 VSUB.n69 0.15675
R539 VSUB.n69 VSUB.n71 0.15675
R540 VSUB.n71 VSUB.n73 0.15675
R541 VSUB.n73 VSUB.n75 0.15675
R542 VSUB.n75 VSUB.n77 0.15675
R543 VSUB.n77 VSUB.n79 0.15675
R544 VSUB.n79 VSUB.n81 0.15675
R545 VSUB.n81 VSUB.n168 0.09425
R546 VSUB VSUB.n82 9.3005
R547 VSUB.n84 VSUB.n85 4.28224
R548 VSUB.n87 VSUB.n86 9.3005
R549 VSUB.n89 VSUB.n88 9.3005
R550 VSUB.n91 VSUB.n90 9.3005
R551 VSUB.n167 VSUB.n92 9.3005
R552 VSUB.n87 VSUB.n84 2.68753
R553 VSUB.n89 VSUB.n87 0.15675
R554 VSUB.n91 VSUB.n89 0.15675
R555 VSUB.n167 VSUB.n91 0.15675
R556 VSUB VSUB.n167 0.09425
R557 VSUB.n163 VSUB.n164 250.349
R558 VSUB.n136 VSUB.n157 250.349
R559 VSUB.n85 VSUB.n93 585
R560 VSUB.n137 VSUB.n94 84.306
R561 VSUB.n86 VSUB.n94 585
R562 VSUB.n157 VSUB.n137 250.349
R563 VSUB.n88 VSUB.n95 585
R564 VSUB.n138 VSUB.n96 84.306
R565 VSUB.n90 VSUB.n96 585
R566 VSUB.n157 VSUB.n138 250.349
R567 VSUB.n92 VSUB.n97 585
R568 VSUB.n98 VSUB.n139 84.306
R569 VSUB.n82 VSUB.n98 585
R570 VSUB.n157 VSUB.n139 250.349
R571 VSUB.n8 VSUB.n99 585
R572 VSUB.n100 VSUB.n140 84.306
R573 VSUB.n10 VSUB.n100 585
R574 VSUB.n157 VSUB.n140 250.349
R575 VSUB.n12 VSUB.n101 585
R576 VSUB.n102 VSUB.n141 84.306
R577 VSUB.n14 VSUB.n102 585
R578 VSUB.n157 VSUB.n141 250.349
R579 VSUB.n16 VSUB.n103 585
R580 VSUB.n104 VSUB.n142 84.306
R581 VSUB.n18 VSUB.n104 585
R582 VSUB.n157 VSUB.n142 250.349
R583 VSUB.n20 VSUB.n105 585
R584 VSUB.n106 VSUB.n143 84.306
R585 VSUB.n22 VSUB.n106 585
R586 VSUB.n157 VSUB.n143 250.349
R587 VSUB.n24 VSUB.n107 585
R588 VSUB.n108 VSUB.n144 84.306
R589 VSUB.n26 VSUB.n108 585
R590 VSUB.n157 VSUB.n144 250.349
R591 VSUB.n28 VSUB.n109 585
R592 VSUB.n110 VSUB.n145 84.306
R593 VSUB.n30 VSUB.n110 585
R594 VSUB.n157 VSUB.n145 250.349
R595 VSUB.n32 VSUB.n111 585
R596 VSUB.n112 VSUB.n146 84.306
R597 VSUB.n34 VSUB.n112 585
R598 VSUB.n157 VSUB.n146 250.349
R599 VSUB.n36 VSUB.n113 585
R600 VSUB.n114 VSUB.n147 84.306
R601 VSUB.n38 VSUB.n114 585
R602 VSUB.n157 VSUB.n147 250.349
R603 VSUB.n40 VSUB.n115 585
R604 VSUB.n116 VSUB.n148 84.306
R605 VSUB.n42 VSUB.n116 585
R606 VSUB.n157 VSUB.n148 250.349
R607 VSUB.n44 VSUB.n117 585
R608 VSUB.n118 VSUB.n149 84.306
R609 VSUB.n46 VSUB.n118 585
R610 VSUB.n157 VSUB.n149 250.349
R611 VSUB.n48 VSUB.n119 585
R612 VSUB.n120 VSUB.n150 84.306
R613 VSUB.n50 VSUB.n120 585
R614 VSUB.n157 VSUB.n150 250.349
R615 VSUB.n52 VSUB.n121 585
R616 VSUB.n122 VSUB.n151 84.306
R617 VSUB.n54 VSUB.n122 585
R618 VSUB.n157 VSUB.n151 250.349
R619 VSUB.n56 VSUB.n123 585
R620 VSUB.n124 VSUB.n152 84.306
R621 VSUB.n58 VSUB.n124 585
R622 VSUB.n157 VSUB.n152 250.349
R623 VSUB.n60 VSUB.n125 585
R624 VSUB.n126 VSUB.n153 84.306
R625 VSUB.n62 VSUB.n126 585
R626 VSUB.n157 VSUB.n153 250.349
R627 VSUB.n64 VSUB.n127 585
R628 VSUB.n128 VSUB.n154 84.306
R629 VSUB.n66 VSUB.n128 585
R630 VSUB.n157 VSUB.n154 250.349
R631 VSUB.n68 VSUB.n129 585
R632 VSUB.n130 VSUB.n155 84.306
R633 VSUB.n70 VSUB.n130 585
R634 VSUB.n157 VSUB.n155 250.349
R635 VSUB.n72 VSUB.n131 585
R636 VSUB.n132 VSUB.n156 84.306
R637 VSUB.n74 VSUB.n132 585
R638 VSUB.n157 VSUB.n156 250.349
R639 VSUB.n76 VSUB.n133 585
R640 VSUB.n157 VSUB.n134 585
R641 VSUB.n78 VSUB.n134 585
R642 VSUB.n135 VSUB.n158 84.306
R643 VSUB.n80 VSUB.n135 585
R644 VSUB.n157 VSUB.n158 250.349
R645 VSUB.n1 VSUB.n159 585
R646 VSUB.n160 VSUB.n162 84.306
R647 VSUB.n3 VSUB.n160 585
R648 VSUB.n164 VSUB.n162 250.349
R649 VSUB.n5 VSUB.n161 585
R650 VSUB.n166 VSUB.n163 84.306
R651 VSUB.n7 VSUB.n166 585
R652 VSUB.n136 VSUB.n84 673.659
R653 VSUB.n85 VSUB.n86 16.0005
R654 VSUB.n86 VSUB.n88 16.0005
R655 VSUB.n88 VSUB.n90 16.0005
R656 VSUB.n90 VSUB.n92 16.0005
R657 VSUB.n92 VSUB.n82 16.0005
R658 VSUB.n82 VSUB.n8 16.0005
R659 VSUB.n8 VSUB.n10 16.0005
R660 VSUB.n10 VSUB.n12 16.0005
R661 VSUB.n12 VSUB.n14 16.0005
R662 VSUB.n14 VSUB.n16 16.0005
R663 VSUB.n16 VSUB.n18 16.0005
R664 VSUB.n18 VSUB.n20 16.0005
R665 VSUB.n20 VSUB.n22 16.0005
R666 VSUB.n22 VSUB.n24 16.0005
R667 VSUB.n24 VSUB.n26 16.0005
R668 VSUB.n26 VSUB.n28 16.0005
R669 VSUB.n28 VSUB.n30 16.0005
R670 VSUB.n30 VSUB.n32 16.0005
R671 VSUB.n32 VSUB.n34 16.0005
R672 VSUB.n34 VSUB.n36 16.0005
R673 VSUB.n36 VSUB.n38 16.0005
R674 VSUB.n38 VSUB.n40 16.0005
R675 VSUB.n40 VSUB.n42 16.0005
R676 VSUB.n42 VSUB.n44 16.0005
R677 VSUB.n44 VSUB.n46 16.0005
R678 VSUB.n46 VSUB.n48 16.0005
R679 VSUB.n48 VSUB.n50 16.0005
R680 VSUB.n50 VSUB.n52 16.0005
R681 VSUB.n52 VSUB.n54 16.0005
R682 VSUB.n54 VSUB.n56 16.0005
R683 VSUB.n56 VSUB.n58 16.0005
R684 VSUB.n58 VSUB.n60 16.0005
R685 VSUB.n60 VSUB.n62 16.0005
R686 VSUB.n62 VSUB.n64 16.0005
R687 VSUB.n64 VSUB.n66 16.0005
R688 VSUB.n66 VSUB.n68 16.0005
R689 VSUB.n68 VSUB.n70 16.0005
R690 VSUB.n70 VSUB.n72 16.0005
R691 VSUB.n72 VSUB.n74 16.0005
R692 VSUB.n74 VSUB.n76 16.0005
R693 VSUB.n76 VSUB.n78 16.0005
R694 VSUB.n78 VSUB.n80 16.0005
R695 VSUB.n80 VSUB.n1 16.0005
R696 VSUB.n1 VSUB.n3 16.0005
R697 VSUB.n3 VSUB.n5 16.0005
R698 VSUB.n5 VSUB.n7 16.0005
R699 VSUB.n93 VSUB.n136 84.306
R700 VSUB.n93 VSUB.n94 197
R701 VSUB.n95 VSUB.n137 84.306
R702 VSUB.n95 VSUB.n96 197
R703 VSUB.n97 VSUB.n138 84.306
R704 VSUB.n97 VSUB.n98 197
R705 VSUB.n139 VSUB.n99 84.306
R706 VSUB.n99 VSUB.n100 197
R707 VSUB.n140 VSUB.n101 84.306
R708 VSUB.n101 VSUB.n102 197
R709 VSUB.n141 VSUB.n103 84.306
R710 VSUB.n103 VSUB.n104 197
R711 VSUB.n142 VSUB.n105 84.306
R712 VSUB.n105 VSUB.n106 197
R713 VSUB.n143 VSUB.n107 84.306
R714 VSUB.n107 VSUB.n108 197
R715 VSUB.n144 VSUB.n109 84.306
R716 VSUB.n109 VSUB.n110 197
R717 VSUB.n145 VSUB.n111 84.306
R718 VSUB.n111 VSUB.n112 197
R719 VSUB.n146 VSUB.n113 84.306
R720 VSUB.n113 VSUB.n114 197
R721 VSUB.n147 VSUB.n115 84.306
R722 VSUB.n115 VSUB.n116 197
R723 VSUB.n148 VSUB.n117 84.306
R724 VSUB.n117 VSUB.n118 197
R725 VSUB.n149 VSUB.n119 84.306
R726 VSUB.n119 VSUB.n120 197
R727 VSUB.n150 VSUB.n121 84.306
R728 VSUB.n121 VSUB.n122 197
R729 VSUB.n151 VSUB.n123 84.306
R730 VSUB.n123 VSUB.n124 197
R731 VSUB.n152 VSUB.n125 84.306
R732 VSUB.n125 VSUB.n126 197
R733 VSUB.n153 VSUB.n127 84.306
R734 VSUB.n127 VSUB.n128 197
R735 VSUB.n154 VSUB.n129 84.306
R736 VSUB.n129 VSUB.n130 197
R737 VSUB.n155 VSUB.n131 84.306
R738 VSUB.n131 VSUB.n132 197
R739 VSUB.n156 VSUB.n133 84.306
R740 VSUB.n133 VSUB.n134 197
R741 VSUB.n134 VSUB.n135 197
R742 VSUB.n158 VSUB.n159 84.306
R743 VSUB.n159 VSUB.n160 197
R744 VSUB.n162 VSUB.n161 84.306
R745 VSUB.n161 VSUB.n166 197
R746 VSUB.n163 VSUB.n2 673.659
R747 VSUB.t0 VSUB.n165 41.2183
R748 VSUB.n164 VSUB.t0 727.037
R749 VSUB.n165 VSUB.t4 288.988
R750 VSUB.n165 VSUB.t2 63.4366
R751 VSUB.t2 VSUB.n157 1118.94
R752 VSUB VSUB.n83 30.208
R753 VSUB.n83 VSUB.t6 15.6755
R754 VSUB.n83 VSUB.t5 15.6755
C0 ve vdd 3.66117f
C1 pbias vdd 4.84168f
C2 vdd nd055 1.98573f
C3 pbias ve 1.51653f
C4 ve nd055 0.40164f
C5 pbias VSUB 0.54101f
C6 nd055 VSUB 1.22193f
C7 ve VSUB 12.51461f
C8 vdd VSUB 70.05923f
C9 vdd.n0 VSUB 0.23325f
C10 vdd.n1 VSUB 3.97889f
C11 vdd.n2 VSUB 0.01109f
C12 vdd.n106 VSUB 0.01149f
C13 vdd.n108 VSUB 0.01711f
C14 vdd.n145 VSUB 0.01711f
C15 vdd.n146 VSUB 0.25192f
C16 vdd.t2 VSUB 0.10245f
C17 vdd.t1 VSUB 0.10245f
C18 vdd.n189 VSUB 0.01536f
C19 vdd.n192 VSUB 0.0156f
C20 vdd.n210 VSUB 0.0156f
C21 vdd.n211 VSUB 0.01538f
C22 vdd.n227 VSUB 0.01237f
C23 vdd.n228 VSUB 0.01638f
C24 vdd.n232 VSUB 0.01638f
C25 vdd.n233 VSUB 0.01959f
C26 vdd.n249 VSUB 3.01706f
C27 vdd.t0 VSUB 6.33879f
C28 ve.t1 VSUB 0.45513f
C29 ve.t2 VSUB 0.45513f
C30 ve.n0 VSUB 0.54513f
C31 ve.t3 VSUB 0.10142p
C32 ve.t0 VSUB 0.9572f
C33 ve.n1 VSUB 1.05953f
C34 ve.t4 VSUB 1.44185f
C35 ve.n2 VSUB 0.48236f
C36 ve.n3 VSUB 0.43735f
C37 ve.t5 VSUB 1.44274f
C38 ve.n4 VSUB 1.10265f
C39 a_n3800_3834.t3 VSUB 0.36966f
C40 a_n3800_3834.n0 VSUB 1.17828f
C41 a_n3800_3834.t1 VSUB 0.42118f
C42 a_n3800_3834.t2 VSUB 0.42118f
C43 a_n3800_3834.n1 VSUB 1.20541f
C44 a_n3800_3834.t5 VSUB 0.68787f
C45 a_n3800_3834.n2 VSUB 0.72449f
C46 a_n3800_3834.t4 VSUB 0.68741f
C47 a_n3800_3834.t0 VSUB 0.10568p
C48 a_n3800_3834.n3 VSUB 1.29076f
C49 a_n3800_1974.t0 VSUB 0.46702f
C50 a_n3800_1974.n0 VSUB 1.36431f
C51 a_n3800_1974.t3 VSUB 1.95124f
C52 a_n3800_1974.n1 VSUB 3.89525f
C53 a_n3800_1974.n2 VSUB 1.28728f
C54 a_n3800_1974.t4 VSUB 0.46702f
C55 a_n3800_1974.t1 VSUB 0.46702f
C56 a_n3800_1974.t2 VSUB 0.46702f
C57 a_n3800_2594.t3 VSUB 0.42779f
C58 a_n3800_2594.n0 VSUB 1.50982f
C59 a_n3800_2594.t1 VSUB 0.49397f
C60 a_n3800_2594.t0 VSUB 0.49397f
C61 a_n3800_2594.n1 VSUB 1.63424f
C62 a_n3800_2594.t4 VSUB 0.95362f
C63 a_n3800_2594.n2 VSUB 0.82706f
C64 a_n3800_2594.t2 VSUB 0.95362f
.ends
