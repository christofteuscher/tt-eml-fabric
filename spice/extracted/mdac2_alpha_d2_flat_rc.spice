* NGSPICE file created from mdac_alpha.ext - technology: sky130A

.subckt mdac_alpha
X0 a_3120_n2000.t0 vcasc a_7020_600.t0 vdd.t5 sky130_fd_pr__pfet_g5v0d10v5 ad=8.8 pd=18.2 as=4.4 ps=9.1 w=8 l=1
X1 a_1980_n2000.t0 vcasc a_4440_600.t0 vdd.t3 sky130_fd_pr__pfet_g5v0d10v5 ad=8.8 pd=18.2 as=4.4 ps=9.1 w=8 l=1
X2 nsum.t5 a0 a_200_n2000.t1 w_80_n3360.t9 sky130_fd_pr__nfet_g5v0d10v5 ad=2.2 pd=5.1 as=4.4 ps=10.2 w=4 l=0.5
X3 nsum.t2 sgn iout_p.t0 w_80_n3360.t6 sky130_fd_pr__nfet_g5v0d10v5 ad=2.2 pd=5.1 as=4.4 ps=10.2 w=4 l=0.5
X4 a_1980_n2000.t1 b0 nsum.t0 w_80_n3360.t0 sky130_fd_pr__nfet_g5v0d10v5 ad=4.4 pd=10.2 as=2.2 ps=5.1 w=4 l=0.5
X5 nsum.t3 b1 a_2480_n2000.t1 w_80_n3360.t7 sky130_fd_pr__nfet_g5v0d10v5 ad=2.2 pd=5.1 as=4.4 ps=10.2 w=4 l=0.5
X6 nmir.t2 sgnb nsum.t1 w_80_n3360.t5 sky130_fd_pr__nfet_g5v0d10v5 ad=4.4 pd=10.2 as=2.2 ps=5.1 w=4 l=0.5
X7 a_840_n2000.t1 a1 nsum.t6 w_80_n3360.t10 sky130_fd_pr__nfet_g5v0d10v5 ad=4.4 pd=10.2 as=2.2 ps=5.1 w=4 l=0.5
X8 a_3120_n2000.t1 b1 nsum.t4 w_80_n3360.t8 sky130_fd_pr__nfet_g5v0d10v5 ad=4.4 pd=10.2 as=2.2 ps=5.1 w=4 l=0.5
X9 a_620_600.t0 vcasc a_200_n2000.t0 vdd.t0 sky130_fd_pr__pfet_g5v0d10v5 ad=4.4 pd=9.1 as=8.8 ps=18.2 w=8 l=1
X10 a_4440_600.t1 vg4 vdd.t17 vdd.t16 sky130_fd_pr__pfet_g5v0d10v5 ad=4.4 pd=9.1 as=4.4 ps=9.1 w=8 l=2
X11 a_1860_600.t1 vg vdd.t9 vdd.t8 sky130_fd_pr__pfet_g5v0d10v5 ad=4.4 pd=9.1 as=4.4 ps=9.1 w=8 l=2
X12 w_80_n3360.t2 nmir.t0 nmir.t1 w_80_n3360.t1 sky130_fd_pr__nfet_g5v0d10v5 ad=4.4 pd=9.1 as=8.8 ps=18.2 w=8 l=2
X13 vdd.t7 vg a_620_600.t1 vdd.t6 sky130_fd_pr__pfet_g5v0d10v5 ad=4.4 pd=9.1 as=4.4 ps=9.1 w=8 l=2
X14 a_5780_600.t0 vcasc a_2480_n2000.t0 vdd.t4 sky130_fd_pr__pfet_g5v0d10v5 ad=4.4 pd=9.1 as=8.8 ps=18.2 w=8 l=1
X15 a_7020_600.t1 vg4 vdd.t13 vdd.t12 sky130_fd_pr__pfet_g5v0d10v5 ad=4.4 pd=9.1 as=4.4 ps=9.1 w=8 l=2
X16 a_3200_600.t0 vcasc a_1340_n2000.t0 vdd.t2 sky130_fd_pr__pfet_g5v0d10v5 ad=4.4 pd=9.1 as=8.8 ps=18.2 w=8 l=1
X17 iout_n.t0 nmir.t3 w_80_n3360.t4 w_80_n3360.t3 sky130_fd_pr__nfet_g5v0d10v5 ad=8.8 pd=18.2 as=4.4 ps=9.1 w=8 l=2
X18 a_840_n2000.t0 vcasc a_1860_600.t0 vdd.t1 sky130_fd_pr__pfet_g5v0d10v5 ad=8.8 pd=18.2 as=4.4 ps=9.1 w=8 l=1
X19 nsum.t7 a1 a_1340_n2000.t1 w_80_n3360.t11 sky130_fd_pr__nfet_g5v0d10v5 ad=2.2 pd=5.1 as=4.4 ps=10.2 w=4 l=0.5
X20 vdd.t11 vg a_3200_600.t1 vdd.t10 sky130_fd_pr__pfet_g5v0d10v5 ad=4.4 pd=9.1 as=4.4 ps=9.1 w=8 l=2
X21 vdd.t15 vg4 a_5780_600.t1 vdd.t14 sky130_fd_pr__pfet_g5v0d10v5 ad=4.4 pd=9.1 as=4.4 ps=9.1 w=8 l=2
R0 iout_n iout_n.t0 22.1165
R1 iout_p iout_p.t0 44.3316
R2 nsum.n0 nsum.t7 15.6755
R3 nsum.n0 nsum.t0 15.6755
R4 nsum.n5 nsum.n0 36.6297
R5 nsum.n5 nsum.n3 0.6585
R6 nsum.n3 nsum.n4 37.2871
R7 nsum.n4 nsum.t2 15.6755
R8 nsum.n4 nsum.t1 15.6755
R9 nsum.n3 nsum.n2 36.6291
R10 nsum.n2 nsum.t3 15.6755
R11 nsum.n2 nsum.t4 15.6755
R12 nsum nsum.n5 4.0685
R13 nsum nsum.n1 33.2192
R14 nsum.n1 nsum.t5 15.6755
R15 nsum.n1 nsum.t6 15.6755
R16 nmir nmir.t2 63.4966
R17 nmir nmir.n0 0.46925
R18 nmir.n0 nmir.t0 278.053
R19 nmir.n0 nmir.t3 279.022
R20 nmir nmir.t1 26.6488
R21 a_3120_n2000.t1 a_3120_n2000.t0 129.018
R22 a_7020_600.t0 a_7020_600.t1 26.263
R23 a_5780_600.t0 a_5780_600.t1 26.263
R24 a_2480_n2000.t1 a_2480_n2000.t0 126.612
R25 a_1980_n2000.t1 a_1980_n2000.t0 126.457
R26 a_4440_600.t0 a_4440_600.t1 26.263
R27 a_3200_600.t0 a_3200_600.t1 26.263
R28 a_1340_n2000.t1 a_1340_n2000.t0 124.05
R29 a_840_n2000.t1 a_840_n2000.t0 123.894
R30 a_1860_600.t0 a_1860_600.t1 26.263
R31 a_620_600.t0 a_620_600.t1 26.263
R32 a_200_n2000.t1 a_200_n2000.t0 121.519
R33 vdd.t7 vdd.n0 13.1318
R34 vdd.n0 vdd.t9 13.1318
R35 vdd.n288 vdd.n0 41.2465
R36 vdd.n1 vdd.n2 4.28224
R37 vdd.n4 vdd.n3 9.3005
R38 vdd.n6 vdd.n5 9.3005
R39 vdd.n8 vdd.n7 9.3005
R40 vdd.n10 vdd.n9 9.3005
R41 vdd.n12 vdd.n11 9.3005
R42 vdd.n14 vdd.n13 9.3005
R43 vdd.n16 vdd.n15 9.3005
R44 vdd.n18 vdd.n17 9.3005
R45 vdd.n20 vdd.n19 9.3005
R46 vdd.n22 vdd.n21 9.3005
R47 vdd.n24 vdd.n23 9.3005
R48 vdd.n26 vdd.n25 9.3005
R49 vdd.n28 vdd.n27 9.3005
R50 vdd.n30 vdd.n29 9.3005
R51 vdd.n32 vdd.n31 9.3005
R52 vdd.n34 vdd.n33 9.3005
R53 vdd.n36 vdd.n35 9.3005
R54 vdd.n38 vdd.n37 9.3005
R55 vdd.n40 vdd.n39 9.3005
R56 vdd.n42 vdd.n41 9.3005
R57 vdd.n44 vdd.n43 9.3005
R58 vdd.n46 vdd.n45 9.3005
R59 vdd.n48 vdd.n47 9.3005
R60 vdd.n50 vdd.n49 9.3005
R61 vdd.n52 vdd.n51 9.3005
R62 vdd.n54 vdd.n53 9.3005
R63 vdd.n56 vdd.n55 9.3005
R64 vdd.n58 vdd.n57 9.3005
R65 vdd.n60 vdd.n59 9.3005
R66 vdd.n62 vdd.n61 9.3005
R67 vdd.n64 vdd.n63 9.3005
R68 vdd.n66 vdd.n65 9.3005
R69 vdd.n68 vdd.n67 9.3005
R70 vdd.n70 vdd.n69 9.3005
R71 vdd.n73 vdd.n71 9.3005
R72 vdd.n75 vdd.n74 9.3005
R73 vdd.n77 vdd.n76 9.3005
R74 vdd.n79 vdd.n78 9.3005
R75 vdd.n81 vdd.n80 9.3005
R76 vdd.n83 vdd.n82 9.3005
R77 vdd.n85 vdd.n84 9.3005
R78 vdd.n87 vdd.n86 9.3005
R79 vdd.n89 vdd.n88 9.3005
R80 vdd.n91 vdd.n90 9.3005
R81 vdd.n93 vdd.n92 9.3005
R82 vdd.n95 vdd.n94 9.3005
R83 vdd.n97 vdd.n96 9.3005
R84 vdd.n99 vdd.n98 9.3005
R85 vdd.n101 vdd.n100 9.3005
R86 vdd.n103 vdd.n102 9.3005
R87 vdd.n105 vdd.n104 9.3005
R88 vdd.n107 vdd.n106 9.3005
R89 vdd.n109 vdd.n108 9.3005
R90 vdd.n111 vdd.n110 9.3005
R91 vdd.n113 vdd.n112 9.3005
R92 vdd.n115 vdd.n114 9.3005
R93 vdd.n117 vdd.n116 9.3005
R94 vdd.n119 vdd.n118 9.3005
R95 vdd.n121 vdd.n120 9.3005
R96 vdd.n123 vdd.n122 9.3005
R97 vdd.n125 vdd.n124 9.3005
R98 vdd.n127 vdd.n126 9.3005
R99 vdd.n129 vdd.n128 9.3005
R100 vdd.n131 vdd.n130 9.3005
R101 vdd.n133 vdd.n132 9.3005
R102 vdd.n135 vdd.n134 9.3005
R103 vdd.n137 vdd.n136 9.3005
R104 vdd.n139 vdd.n138 9.3005
R105 vdd.n141 vdd.n140 9.3005
R106 vdd.n143 vdd.n142 4.28224
R107 vdd.n4 vdd.n1 2.68753
R108 vdd.n6 vdd.n4 0.15675
R109 vdd.n8 vdd.n6 0.15675
R110 vdd.n10 vdd.n8 0.15675
R111 vdd.n12 vdd.n10 0.15675
R112 vdd.n14 vdd.n12 0.15675
R113 vdd.n16 vdd.n14 0.15675
R114 vdd.n18 vdd.n16 0.15675
R115 vdd.n20 vdd.n18 0.15675
R116 vdd.n288 vdd.n20 0.03175
R117 vdd.n22 vdd.n288 0.1255
R118 vdd.n24 vdd.n22 0.15675
R119 vdd.n26 vdd.n24 0.15675
R120 vdd.n28 vdd.n26 0.15675
R121 vdd.n30 vdd.n28 0.15675
R122 vdd.n32 vdd.n30 0.15675
R123 vdd.n34 vdd.n32 0.15675
R124 vdd.n36 vdd.n34 0.15675
R125 vdd.n38 vdd.n36 0.15675
R126 vdd.n40 vdd.n38 0.15675
R127 vdd.n42 vdd.n40 0.15675
R128 vdd.n44 vdd.n42 0.15675
R129 vdd.n46 vdd.n44 0.15675
R130 vdd.n48 vdd.n46 0.15675
R131 vdd.n50 vdd.n48 0.15675
R132 vdd.n52 vdd.n50 0.15675
R133 vdd.n54 vdd.n52 0.15675
R134 vdd.n56 vdd.n54 0.15675
R135 vdd.n58 vdd.n56 0.15675
R136 vdd.n60 vdd.n58 0.15675
R137 vdd.n62 vdd.n60 0.15675
R138 vdd.n64 vdd.n62 0.15675
R139 vdd.n66 vdd.n64 0.15675
R140 vdd.n68 vdd.n66 0.15675
R141 vdd.n70 vdd.n68 0.15675
R142 vdd.n73 vdd.n70 0.15675
R143 vdd.n75 vdd.n73 0.15675
R144 vdd.n77 vdd.n75 0.15675
R145 vdd.n79 vdd.n77 0.15675
R146 vdd.n81 vdd.n79 0.15675
R147 vdd.n83 vdd.n81 0.15675
R148 vdd.n85 vdd.n83 0.15675
R149 vdd.n87 vdd.n85 0.15675
R150 vdd.n89 vdd.n87 0.15675
R151 vdd.n91 vdd.n89 0.15675
R152 vdd.n93 vdd.n91 0.15675
R153 vdd.n95 vdd.n93 0.15675
R154 vdd.n97 vdd.n95 0.15675
R155 vdd.n99 vdd.n97 0.15675
R156 vdd.n101 vdd.n99 0.15675
R157 vdd.n103 vdd.n101 0.15675
R158 vdd.n105 vdd.n103 0.15675
R159 vdd.n107 vdd.n105 0.15675
R160 vdd.n109 vdd.n107 0.15675
R161 vdd.n111 vdd.n109 0.15675
R162 vdd.n113 vdd.n111 0.15675
R163 vdd.n115 vdd.n113 0.15675
R164 vdd.n117 vdd.n115 0.15675
R165 vdd.n119 vdd.n117 0.15675
R166 vdd.n121 vdd.n119 0.15675
R167 vdd.n123 vdd.n121 0.15675
R168 vdd.n287 vdd.n123 0.1255
R169 vdd.n287 vdd.n125 0.03175
R170 vdd.n125 vdd.n127 0.15675
R171 vdd.n127 vdd.n129 0.15675
R172 vdd.n129 vdd.n131 0.15675
R173 vdd.n131 vdd.n133 0.15675
R174 vdd.n133 vdd.n135 0.15675
R175 vdd.n135 vdd.n137 0.15675
R176 vdd.n137 vdd.n139 0.15675
R177 vdd.n139 vdd.n141 0.15675
R178 vdd.n141 vdd.n143 2.68753
R179 vdd vdd.n286 41.2313
R180 vdd vdd.n287 0.016125
R181 vdd.n286 vdd.t15 13.1318
R182 vdd.n286 vdd.t13 13.1318
R183 vdd.n145 vdd.n144 41.0422
R184 vdd.n2 vdd.n145 185
R185 vdd.n146 vdd.n147 185
R186 vdd.n3 vdd.n147 185
R187 vdd.n148 vdd.n149 185
R188 vdd.n5 vdd.n149 185
R189 vdd.n151 vdd.n150 185
R190 vdd.n7 vdd.n151 185
R191 vdd.n153 vdd.n152 185
R192 vdd.n9 vdd.n153 185
R193 vdd.n155 vdd.n154 185
R194 vdd.n11 vdd.n155 185
R195 vdd.n157 vdd.n156 185
R196 vdd.n13 vdd.n157 185
R197 vdd.n159 vdd.n158 185
R198 vdd.n15 vdd.n159 185
R199 vdd.n161 vdd.n160 185
R200 vdd.n17 vdd.n161 185
R201 vdd.n163 vdd.n162 185
R202 vdd.n19 vdd.n163 185
R203 vdd.n165 vdd.n164 185
R204 vdd.n21 vdd.n165 185
R205 vdd.n167 vdd.n166 185
R206 vdd.n23 vdd.n167 185
R207 vdd.n169 vdd.n168 185
R208 vdd.n25 vdd.n169 185
R209 vdd.n171 vdd.n170 185
R210 vdd.n27 vdd.n171 185
R211 vdd.n173 vdd.n172 185
R212 vdd.n29 vdd.n173 185
R213 vdd.n175 vdd.n174 185
R214 vdd.n31 vdd.n175 185
R215 vdd.n177 vdd.n176 185
R216 vdd.n33 vdd.n177 185
R217 vdd.n179 vdd.n178 185
R218 vdd.n35 vdd.n179 185
R219 vdd.n181 vdd.n180 185
R220 vdd.n37 vdd.n181 185
R221 vdd.n183 vdd.n182 185
R222 vdd.n39 vdd.n183 185
R223 vdd.n185 vdd.n184 185
R224 vdd.n41 vdd.n185 185
R225 vdd.n187 vdd.n186 185
R226 vdd.n43 vdd.n187 185
R227 vdd.n189 vdd.n188 185
R228 vdd.n45 vdd.n189 185
R229 vdd.n191 vdd.n190 185
R230 vdd.n47 vdd.n191 185
R231 vdd.n193 vdd.n192 185
R232 vdd.n49 vdd.n193 185
R233 vdd.n195 vdd.n194 185
R234 vdd.n51 vdd.n195 185
R235 vdd.n197 vdd.n196 185
R236 vdd.n53 vdd.n197 185
R237 vdd.n199 vdd.n198 185
R238 vdd.n55 vdd.n199 185
R239 vdd.n201 vdd.n200 185
R240 vdd.n57 vdd.n201 185
R241 vdd.n203 vdd.n202 185
R242 vdd.n59 vdd.n203 185
R243 vdd.n205 vdd.n204 185
R244 vdd.n61 vdd.n205 185
R245 vdd.n207 vdd.n206 185
R246 vdd.n63 vdd.n207 185
R247 vdd.n209 vdd.n208 185
R248 vdd.n65 vdd.n209 185
R249 vdd.n211 vdd.n210 185
R250 vdd.n67 vdd.n211 185
R251 vdd.n213 vdd.n212 185
R252 vdd.n69 vdd.n213 185
R253 vdd.n215 vdd.n214 185
R254 vdd.n71 vdd.n215 185
R255 vdd.n217 vdd.n216 185
R256 vdd.n74 vdd.n217 185
R257 vdd.n219 vdd.n218 185
R258 vdd.n76 vdd.n219 185
R259 vdd.n221 vdd.n220 185
R260 vdd.n78 vdd.n221 185
R261 vdd.n223 vdd.n222 185
R262 vdd.n80 vdd.n223 185
R263 vdd.n225 vdd.n224 185
R264 vdd.n82 vdd.n225 185
R265 vdd.n227 vdd.n226 185
R266 vdd.n84 vdd.n227 185
R267 vdd.n229 vdd.n228 185
R268 vdd.n86 vdd.n229 185
R269 vdd.n231 vdd.n230 185
R270 vdd.n88 vdd.n231 185
R271 vdd.n233 vdd.n232 185
R272 vdd.n90 vdd.n233 185
R273 vdd.n235 vdd.n234 185
R274 vdd.n92 vdd.n235 185
R275 vdd.n237 vdd.n236 185
R276 vdd.n94 vdd.n237 185
R277 vdd.n239 vdd.n238 185
R278 vdd.n96 vdd.n239 185
R279 vdd.n241 vdd.n240 185
R280 vdd.n98 vdd.n241 185
R281 vdd.n243 vdd.n242 185
R282 vdd.n100 vdd.n243 185
R283 vdd.n245 vdd.n244 185
R284 vdd.n102 vdd.n245 185
R285 vdd.n247 vdd.n246 185
R286 vdd.n104 vdd.n247 185
R287 vdd.n249 vdd.n248 185
R288 vdd.n106 vdd.n249 185
R289 vdd.n251 vdd.n250 185
R290 vdd.n108 vdd.n251 185
R291 vdd.n253 vdd.n252 185
R292 vdd.n110 vdd.n253 185
R293 vdd.n255 vdd.n254 185
R294 vdd.n112 vdd.n255 185
R295 vdd.n257 vdd.n256 185
R296 vdd.n114 vdd.n257 185
R297 vdd.n259 vdd.n258 185
R298 vdd.n116 vdd.n259 185
R299 vdd.n261 vdd.n260 185
R300 vdd.n118 vdd.n261 185
R301 vdd.n263 vdd.n262 185
R302 vdd.n120 vdd.n263 185
R303 vdd.n265 vdd.n264 185
R304 vdd.n122 vdd.n265 185
R305 vdd.n267 vdd.n266 185
R306 vdd.n124 vdd.n267 185
R307 vdd.n269 vdd.n268 185
R308 vdd.n126 vdd.n269 185
R309 vdd.n271 vdd.n270 185
R310 vdd.n128 vdd.n271 185
R311 vdd.n273 vdd.n272 185
R312 vdd.n130 vdd.n273 185
R313 vdd.n275 vdd.n274 185
R314 vdd.n132 vdd.n275 185
R315 vdd.n277 vdd.n276 185
R316 vdd.n134 vdd.n277 185
R317 vdd.n279 vdd.n278 185
R318 vdd.n136 vdd.n279 185
R319 vdd.n280 vdd.n281 185
R320 vdd.n138 vdd.n281 185
R321 vdd.n282 vdd.n283 185
R322 vdd.n140 vdd.n283 185
R323 vdd.n142 vdd.n285 185
R324 vdd.n284 vdd.n143 237.024
R325 vdd.n144 vdd.n1 237.024
R326 vdd.n2 vdd.n3 16.0005
R327 vdd.n3 vdd.n5 16.0005
R328 vdd.n5 vdd.n7 16.0005
R329 vdd.n7 vdd.n9 16.0005
R330 vdd.n9 vdd.n11 16.0005
R331 vdd.n11 vdd.n13 16.0005
R332 vdd.n13 vdd.n15 16.0005
R333 vdd.n15 vdd.n17 16.0005
R334 vdd.n17 vdd.n19 16.0005
R335 vdd.n19 vdd.n21 16.0005
R336 vdd.n21 vdd.n23 16.0005
R337 vdd.n23 vdd.n25 16.0005
R338 vdd.n25 vdd.n27 16.0005
R339 vdd.n27 vdd.n29 16.0005
R340 vdd.n29 vdd.n31 16.0005
R341 vdd.n31 vdd.n33 16.0005
R342 vdd.n33 vdd.n35 16.0005
R343 vdd.n35 vdd.n37 16.0005
R344 vdd.n37 vdd.n39 16.0005
R345 vdd.n39 vdd.n41 16.0005
R346 vdd.n41 vdd.n43 16.0005
R347 vdd.n43 vdd.n45 16.0005
R348 vdd.n45 vdd.n47 16.0005
R349 vdd.n47 vdd.n49 16.0005
R350 vdd.n49 vdd.n51 16.0005
R351 vdd.n51 vdd.n53 16.0005
R352 vdd.n53 vdd.n55 16.0005
R353 vdd.n55 vdd.n57 16.0005
R354 vdd.n57 vdd.n59 16.0005
R355 vdd.n59 vdd.n61 16.0005
R356 vdd.n61 vdd.n63 16.0005
R357 vdd.n63 vdd.n65 16.0005
R358 vdd.n65 vdd.n67 16.0005
R359 vdd.n67 vdd.n69 16.0005
R360 vdd.n69 vdd.n71 16.0005
R361 vdd.n71 vdd.n74 16.0005
R362 vdd.n74 vdd.n76 16.0005
R363 vdd.n76 vdd.n78 16.0005
R364 vdd.n78 vdd.n80 16.0005
R365 vdd.n80 vdd.n82 16.0005
R366 vdd.n82 vdd.n84 16.0005
R367 vdd.n84 vdd.n86 16.0005
R368 vdd.n86 vdd.n88 16.0005
R369 vdd.n88 vdd.n90 16.0005
R370 vdd.n90 vdd.n92 16.0005
R371 vdd.n92 vdd.n94 16.0005
R372 vdd.n94 vdd.n96 16.0005
R373 vdd.n96 vdd.n98 16.0005
R374 vdd.n98 vdd.n100 16.0005
R375 vdd.n100 vdd.n102 16.0005
R376 vdd.n102 vdd.n104 16.0005
R377 vdd.n104 vdd.n106 16.0005
R378 vdd.n106 vdd.n108 16.0005
R379 vdd.n108 vdd.n110 16.0005
R380 vdd.n110 vdd.n112 16.0005
R381 vdd.n112 vdd.n114 16.0005
R382 vdd.n114 vdd.n116 16.0005
R383 vdd.n116 vdd.n118 16.0005
R384 vdd.n118 vdd.n120 16.0005
R385 vdd.n120 vdd.n122 16.0005
R386 vdd.n122 vdd.n124 16.0005
R387 vdd.n124 vdd.n126 16.0005
R388 vdd.n126 vdd.n128 16.0005
R389 vdd.n128 vdd.n130 16.0005
R390 vdd.n130 vdd.n132 16.0005
R391 vdd.n132 vdd.n134 16.0005
R392 vdd.n134 vdd.n136 16.0005
R393 vdd.n136 vdd.n138 16.0005
R394 vdd.n138 vdd.n140 16.0005
R395 vdd.n140 vdd.n142 16.0005
R396 vdd.n145 vdd.n147 114.001
R397 vdd.n147 vdd.n149 114.001
R398 vdd.n149 vdd.n151 114.001
R399 vdd.n151 vdd.n153 114.001
R400 vdd.n153 vdd.n155 114.001
R401 vdd.n155 vdd.n157 114.001
R402 vdd.n157 vdd.n159 114.001
R403 vdd.n159 vdd.n161 114.001
R404 vdd.n161 vdd.n163 114.001
R405 vdd.n163 vdd.n165 114.001
R406 vdd.n165 vdd.n167 114.001
R407 vdd.n167 vdd.n169 114.001
R408 vdd.n169 vdd.n171 114.001
R409 vdd.n171 vdd.n173 114.001
R410 vdd.n173 vdd.n175 114.001
R411 vdd.n175 vdd.n177 114.001
R412 vdd.n177 vdd.n179 114.001
R413 vdd.n179 vdd.n181 114.001
R414 vdd.n181 vdd.n183 114.001
R415 vdd.n183 vdd.n185 114.001
R416 vdd.n185 vdd.n187 114.001
R417 vdd.n187 vdd.n189 114.001
R418 vdd.n189 vdd.n191 114.001
R419 vdd.n191 vdd.n193 114.001
R420 vdd.n193 vdd.n195 114.001
R421 vdd.n195 vdd.n197 114.001
R422 vdd.n197 vdd.n199 114.001
R423 vdd.n199 vdd.n201 114.001
R424 vdd.n201 vdd.n203 114.001
R425 vdd.n203 vdd.n205 114.001
R426 vdd.n205 vdd.n207 114.001
R427 vdd.n207 vdd.n209 114.001
R428 vdd.n209 vdd.n211 114.001
R429 vdd.n211 vdd.n213 114.001
R430 vdd.n213 vdd.n215 114.001
R431 vdd.n215 vdd.n217 114.001
R432 vdd.n217 vdd.n219 114.001
R433 vdd.n219 vdd.n221 114.001
R434 vdd.n221 vdd.n223 114.001
R435 vdd.n223 vdd.n225 114.001
R436 vdd.n225 vdd.n227 114.001
R437 vdd.n227 vdd.n229 114.001
R438 vdd.n229 vdd.n231 114.001
R439 vdd.n231 vdd.n233 114.001
R440 vdd.n233 vdd.n235 114.001
R441 vdd.n235 vdd.n237 114.001
R442 vdd.n237 vdd.n239 114.001
R443 vdd.n239 vdd.n241 114.001
R444 vdd.n241 vdd.n243 114.001
R445 vdd.n243 vdd.n245 114.001
R446 vdd.n245 vdd.n247 114.001
R447 vdd.n247 vdd.n249 114.001
R448 vdd.n249 vdd.n251 114.001
R449 vdd.n251 vdd.n253 114.001
R450 vdd.n253 vdd.n255 114.001
R451 vdd.n255 vdd.n257 114.001
R452 vdd.n257 vdd.n259 114.001
R453 vdd.n259 vdd.n261 114.001
R454 vdd.n261 vdd.n263 114.001
R455 vdd.n263 vdd.n265 114.001
R456 vdd.n265 vdd.n267 114.001
R457 vdd.n267 vdd.n269 114.001
R458 vdd.n269 vdd.n271 114.001
R459 vdd.n271 vdd.n273 114.001
R460 vdd.n273 vdd.n275 114.001
R461 vdd.n275 vdd.n277 114.001
R462 vdd.n277 vdd.n279 114.001
R463 vdd.n279 vdd.n281 114.001
R464 vdd.n281 vdd.n283 114.001
R465 vdd.n283 vdd.n285 114.001
R466 vdd.n285 vdd.n284 41.0422
R467 vdd.n144 vdd.t0 104.245
R468 vdd.t0 vdd.n146 2.98792
R469 vdd.n146 vdd.n148 29.8747
R470 vdd.n148 vdd.n150 29.8747
R471 vdd.n150 vdd.n152 29.8747
R472 vdd.n152 vdd.n154 29.8747
R473 vdd.n154 vdd.n156 29.8747
R474 vdd.n156 vdd.t6 2.98792
R475 vdd.t6 vdd.n158 26.8873
R476 vdd.n158 vdd.n160 29.8747
R477 vdd.n160 vdd.n162 29.8747
R478 vdd.n162 vdd.n164 29.8747
R479 vdd.n164 vdd.n166 29.8747
R480 vdd.n166 vdd.n168 29.8747
R481 vdd.n168 vdd.t8 8.96276
R482 vdd.t8 vdd.n170 20.9124
R483 vdd.n170 vdd.n172 29.8747
R484 vdd.n172 vdd.n174 29.8747
R485 vdd.n174 vdd.n176 29.8747
R486 vdd.n176 vdd.n178 29.8747
R487 vdd.n178 vdd.t1 14.9376
R488 vdd.n180 vdd.t1 14.9376
R489 vdd.n180 vdd.n182 29.8747
R490 vdd.n182 vdd.n184 29.8747
R491 vdd.n184 vdd.n186 29.8747
R492 vdd.n186 vdd.n188 29.8747
R493 vdd.n188 vdd.n190 29.8747
R494 vdd.n190 vdd.n192 29.8747
R495 vdd.n192 vdd.n194 29.8747
R496 vdd.n194 vdd.n196 29.8747
R497 vdd.n196 vdd.t2 20.9124
R498 vdd.n198 vdd.t2 8.96276
R499 vdd.n198 vdd.n200 29.8747
R500 vdd.n200 vdd.n202 29.8747
R501 vdd.n202 vdd.n204 29.8747
R502 vdd.n204 vdd.n206 29.8747
R503 vdd.n206 vdd.t10 26.8873
R504 vdd.n208 vdd.t10 2.98792
R505 vdd.n208 vdd.n210 29.8747
R506 vdd.n210 vdd.n212 29.8747
R507 vdd.n212 vdd.n214 29.8747
R508 vdd.n214 vdd.n216 29.8747
R509 vdd.n216 vdd.n218 29.8747
R510 vdd.n218 vdd.n220 29.8747
R511 vdd.n220 vdd.t16 2.98792
R512 vdd.t16 vdd.n222 26.8873
R513 vdd.n222 vdd.n224 29.8747
R514 vdd.n224 vdd.n226 29.8747
R515 vdd.n226 vdd.n228 29.8747
R516 vdd.n228 vdd.n230 29.8747
R517 vdd.n230 vdd.t3 8.96276
R518 vdd.t3 vdd.n232 20.9124
R519 vdd.n232 vdd.n234 29.8747
R520 vdd.n234 vdd.n236 29.8747
R521 vdd.n236 vdd.n238 29.8747
R522 vdd.n238 vdd.n240 29.8747
R523 vdd.n240 vdd.n242 29.8747
R524 vdd.n242 vdd.n244 29.8747
R525 vdd.n244 vdd.n246 29.8747
R526 vdd.n246 vdd.n248 29.8747
R527 vdd.n248 vdd.t4 14.9376
R528 vdd.n250 vdd.t4 14.9376
R529 vdd.n250 vdd.n252 29.8747
R530 vdd.n252 vdd.n254 29.8747
R531 vdd.n254 vdd.n256 29.8747
R532 vdd.n256 vdd.n258 29.8747
R533 vdd.n258 vdd.t14 20.9124
R534 vdd.n260 vdd.t14 8.96276
R535 vdd.n260 vdd.n262 29.8747
R536 vdd.n262 vdd.n264 29.8747
R537 vdd.n264 vdd.n266 29.8747
R538 vdd.n266 vdd.n268 29.8747
R539 vdd.n268 vdd.n270 29.8747
R540 vdd.n270 vdd.t12 26.8873
R541 vdd.n272 vdd.t12 2.98792
R542 vdd.n272 vdd.n274 29.8747
R543 vdd.n274 vdd.n276 29.8747
R544 vdd.n276 vdd.n278 29.8747
R545 vdd.n278 vdd.n280 29.8747
R546 vdd.n282 vdd.n280 29.8747
R547 vdd.t5 vdd.n282 2.98792
R548 vdd.n284 vdd.t5 104.245
R549 vdd.n73 vdd.n72 41.2469
R550 vdd.n72 vdd.t11 13.1318
R551 vdd.n72 vdd.t17 13.1318
R552 w_80_n3360.n2 w_80_n3360.n1 75.7236
R553 w_80_n3360.n3 w_80_n3360.n2 585
R554 w_80_n3360.n4 w_80_n3360.n5 585
R555 w_80_n3360.n6 w_80_n3360.n5 585
R556 w_80_n3360.n7 w_80_n3360.n8 585
R557 w_80_n3360.n9 w_80_n3360.n8 585
R558 w_80_n3360.n11 w_80_n3360.n10 585
R559 w_80_n3360.n12 w_80_n3360.n11 585
R560 w_80_n3360.n14 w_80_n3360.n13 585
R561 w_80_n3360.n15 w_80_n3360.n14 585
R562 w_80_n3360.n17 w_80_n3360.n16 585
R563 w_80_n3360.n18 w_80_n3360.n17 585
R564 w_80_n3360.n20 w_80_n3360.n19 585
R565 w_80_n3360.n21 w_80_n3360.n20 585
R566 w_80_n3360.n23 w_80_n3360.n22 585
R567 w_80_n3360.n24 w_80_n3360.n23 585
R568 w_80_n3360.n26 w_80_n3360.n25 585
R569 w_80_n3360.n27 w_80_n3360.n26 585
R570 w_80_n3360.n29 w_80_n3360.n28 585
R571 w_80_n3360.n30 w_80_n3360.n29 585
R572 w_80_n3360.n32 w_80_n3360.n31 585
R573 w_80_n3360.n33 w_80_n3360.n32 585
R574 w_80_n3360.n35 w_80_n3360.n34 585
R575 w_80_n3360.n36 w_80_n3360.n35 585
R576 w_80_n3360.n38 w_80_n3360.n37 585
R577 w_80_n3360.n39 w_80_n3360.n38 585
R578 w_80_n3360.n41 w_80_n3360.n40 585
R579 w_80_n3360.n42 w_80_n3360.n41 585
R580 w_80_n3360.n44 w_80_n3360.n43 585
R581 w_80_n3360.n45 w_80_n3360.n44 585
R582 w_80_n3360.n47 w_80_n3360.n46 585
R583 w_80_n3360.n48 w_80_n3360.n47 585
R584 w_80_n3360.n50 w_80_n3360.n49 585
R585 w_80_n3360.n51 w_80_n3360.n50 585
R586 w_80_n3360.n53 w_80_n3360.n52 585
R587 w_80_n3360.n54 w_80_n3360.n53 585
R588 w_80_n3360.n55 w_80_n3360.t5 585
R589 w_80_n3360.n56 w_80_n3360.n55 585
R590 w_80_n3360.n58 w_80_n3360.n57 585
R591 w_80_n3360.n59 w_80_n3360.n58 585
R592 w_80_n3360.n61 w_80_n3360.n60 585
R593 w_80_n3360.n62 w_80_n3360.n61 585
R594 w_80_n3360.n64 w_80_n3360.n63 585
R595 w_80_n3360.n65 w_80_n3360.n64 585
R596 w_80_n3360.n67 w_80_n3360.n66 585
R597 w_80_n3360.n68 w_80_n3360.n67 585
R598 w_80_n3360.n70 w_80_n3360.n69 585
R599 w_80_n3360.n71 w_80_n3360.n70 585
R600 w_80_n3360.n73 w_80_n3360.n72 585
R601 w_80_n3360.n74 w_80_n3360.n73 585
R602 w_80_n3360.n76 w_80_n3360.n75 585
R603 w_80_n3360.n77 w_80_n3360.n76 585
R604 w_80_n3360.n79 w_80_n3360.n78 585
R605 w_80_n3360.n80 w_80_n3360.n79 585
R606 w_80_n3360.n82 w_80_n3360.n81 585
R607 w_80_n3360.n83 w_80_n3360.n82 585
R608 w_80_n3360.n85 w_80_n3360.n84 585
R609 w_80_n3360.n86 w_80_n3360.n85 585
R610 w_80_n3360.n88 w_80_n3360.n87 585
R611 w_80_n3360.n89 w_80_n3360.n88 585
R612 w_80_n3360.n91 w_80_n3360.n90 585
R613 w_80_n3360.n92 w_80_n3360.n91 585
R614 w_80_n3360.n94 w_80_n3360.n93 585
R615 w_80_n3360.n95 w_80_n3360.n94 585
R616 w_80_n3360.n97 w_80_n3360.n96 585
R617 w_80_n3360.n98 w_80_n3360.n97 585
R618 w_80_n3360.n100 w_80_n3360.n99 585
R619 w_80_n3360.n101 w_80_n3360.n100 585
R620 w_80_n3360.n103 w_80_n3360.n102 585
R621 w_80_n3360.n104 w_80_n3360.n103 585
R622 w_80_n3360.n106 w_80_n3360.n105 585
R623 w_80_n3360.n107 w_80_n3360.n106 585
R624 w_80_n3360.n109 w_80_n3360.n108 585
R625 w_80_n3360.n110 w_80_n3360.n109 585
R626 w_80_n3360.n111 w_80_n3360.n112 585
R627 w_80_n3360.n113 w_80_n3360.n112 585
R628 w_80_n3360.n114 w_80_n3360.n115 585
R629 w_80_n3360.n116 w_80_n3360.n115 585
R630 w_80_n3360.n117 w_80_n3360.n118 585
R631 w_80_n3360.n119 w_80_n3360.n118 585
R632 w_80_n3360.n120 w_80_n3360.n121 585
R633 w_80_n3360.n122 w_80_n3360.n121 585
R634 w_80_n3360.n123 w_80_n3360.n124 585
R635 w_80_n3360.n125 w_80_n3360.n124 585
R636 w_80_n3360.n126 w_80_n3360.n127 585
R637 w_80_n3360.n128 w_80_n3360.n127 585
R638 w_80_n3360.n129 w_80_n3360.n130 585
R639 w_80_n3360.n131 w_80_n3360.n130 585
R640 w_80_n3360.t11 w_80_n3360.n132 585
R641 w_80_n3360.n133 w_80_n3360.n132 585
R642 w_80_n3360.n134 w_80_n3360.n135 585
R643 w_80_n3360.n136 w_80_n3360.n135 585
R644 w_80_n3360.n137 w_80_n3360.n138 585
R645 w_80_n3360.n139 w_80_n3360.n138 585
R646 w_80_n3360.n140 w_80_n3360.n141 585
R647 w_80_n3360.n141 w_80_n3360.n142 585
R648 w_80_n3360.n143 w_80_n3360.n144 585
R649 w_80_n3360.n144 w_80_n3360.n145 585
R650 w_80_n3360.n146 w_80_n3360.n147 585
R651 w_80_n3360.n147 w_80_n3360.n148 585
R652 w_80_n3360.n149 w_80_n3360.n150 585
R653 w_80_n3360.n150 w_80_n3360.n151 585
R654 w_80_n3360.n152 w_80_n3360.n153 585
R655 w_80_n3360.n153 w_80_n3360.n154 585
R656 w_80_n3360.n155 w_80_n3360.n156 585
R657 w_80_n3360.n156 w_80_n3360.n157 585
R658 w_80_n3360.n158 w_80_n3360.n159 585
R659 w_80_n3360.n159 w_80_n3360.n160 585
R660 w_80_n3360.n161 w_80_n3360.n162 585
R661 w_80_n3360.n162 w_80_n3360.n163 585
R662 w_80_n3360.n164 w_80_n3360.n165 585
R663 w_80_n3360.n165 w_80_n3360.n166 585
R664 w_80_n3360.n167 w_80_n3360.n168 585
R665 w_80_n3360.n168 w_80_n3360.n169 585
R666 w_80_n3360.n170 w_80_n3360.n171 585
R667 w_80_n3360.n0 w_80_n3360.n170 263.543
R668 w_80_n3360.n170 w_80_n3360.n167 114.584
R669 w_80_n3360.n167 w_80_n3360.t9 68.7505
R670 w_80_n3360.t9 w_80_n3360.n164 45.8338
R671 w_80_n3360.n164 w_80_n3360.n161 114.584
R672 w_80_n3360.n161 w_80_n3360.n158 114.584
R673 w_80_n3360.n158 w_80_n3360.t10 91.6672
R674 w_80_n3360.t10 w_80_n3360.n155 22.9172
R675 w_80_n3360.n155 w_80_n3360.n152 114.584
R676 w_80_n3360.n152 w_80_n3360.n149 114.584
R677 w_80_n3360.n149 w_80_n3360.n146 114.584
R678 w_80_n3360.n146 w_80_n3360.n143 114.584
R679 w_80_n3360.n143 w_80_n3360.n140 114.584
R680 w_80_n3360.n140 w_80_n3360.n137 114.584
R681 w_80_n3360.n137 w_80_n3360.n134 114.584
R682 w_80_n3360.n134 w_80_n3360.t11 114.584
R683 w_80_n3360.t11 w_80_n3360.n129 114.584
R684 w_80_n3360.n129 w_80_n3360.n126 114.584
R685 w_80_n3360.n126 w_80_n3360.n123 114.584
R686 w_80_n3360.n123 w_80_n3360.t0 22.9172
R687 w_80_n3360.t0 w_80_n3360.n120 91.6672
R688 w_80_n3360.n120 w_80_n3360.n117 114.584
R689 w_80_n3360.n117 w_80_n3360.n114 114.584
R690 w_80_n3360.n114 w_80_n3360.n111 114.584
R691 w_80_n3360.n111 w_80_n3360.n108 114.584
R692 w_80_n3360.n108 w_80_n3360.n105 114.584
R693 w_80_n3360.n105 w_80_n3360.n102 114.584
R694 w_80_n3360.n102 w_80_n3360.n99 114.584
R695 w_80_n3360.n99 w_80_n3360.t7 45.8338
R696 w_80_n3360.t7 w_80_n3360.n96 68.7505
R697 w_80_n3360.n96 w_80_n3360.n93 114.584
R698 w_80_n3360.n93 w_80_n3360.n90 114.584
R699 w_80_n3360.n90 w_80_n3360.t8 68.7505
R700 w_80_n3360.n87 w_80_n3360.t8 45.8338
R701 w_80_n3360.n87 w_80_n3360.n84 114.584
R702 w_80_n3360.n84 w_80_n3360.n81 114.584
R703 w_80_n3360.n81 w_80_n3360.n78 114.584
R704 w_80_n3360.n78 w_80_n3360.n75 114.584
R705 w_80_n3360.n75 w_80_n3360.n72 114.584
R706 w_80_n3360.n72 w_80_n3360.n69 114.584
R707 w_80_n3360.n69 w_80_n3360.n66 114.584
R708 w_80_n3360.n66 w_80_n3360.t6 91.6672
R709 w_80_n3360.n63 w_80_n3360.t6 22.9172
R710 w_80_n3360.n63 w_80_n3360.n60 114.584
R711 w_80_n3360.n60 w_80_n3360.n57 114.584
R712 w_80_n3360.n57 w_80_n3360.t5 114.584
R713 w_80_n3360.t5 w_80_n3360.n52 114.584
R714 w_80_n3360.n52 w_80_n3360.n49 114.584
R715 w_80_n3360.n49 w_80_n3360.n46 114.584
R716 w_80_n3360.n46 w_80_n3360.n43 114.584
R717 w_80_n3360.n43 w_80_n3360.n40 114.584
R718 w_80_n3360.n40 w_80_n3360.n37 114.584
R719 w_80_n3360.n37 w_80_n3360.n34 114.584
R720 w_80_n3360.n34 w_80_n3360.n31 114.584
R721 w_80_n3360.n31 w_80_n3360.n28 114.584
R722 w_80_n3360.n28 w_80_n3360.t1 80.2088
R723 w_80_n3360.n25 w_80_n3360.t1 34.3755
R724 w_80_n3360.n25 w_80_n3360.n22 114.584
R725 w_80_n3360.n22 w_80_n3360.n19 114.584
R726 w_80_n3360.n19 w_80_n3360.n16 114.584
R727 w_80_n3360.n16 w_80_n3360.n13 114.584
R728 w_80_n3360.n13 w_80_n3360.n10 114.584
R729 w_80_n3360.n10 w_80_n3360.t3 103.126
R730 w_80_n3360.n7 w_80_n3360.t3 11.4588
R731 w_80_n3360.n4 w_80_n3360.n7 114.584
R732 w_80_n3360.n1 w_80_n3360.n4 391.937
R733 w_80_n3360.n173 w_80_n3360.n169 4.28224
R734 w_80_n3360.n174 w_80_n3360.n166 9.3005
R735 w_80_n3360.n175 w_80_n3360.n163 9.3005
R736 w_80_n3360.n176 w_80_n3360.n160 9.3005
R737 w_80_n3360.n177 w_80_n3360.n157 9.3005
R738 w_80_n3360.n178 w_80_n3360.n154 9.3005
R739 w_80_n3360.n179 w_80_n3360.n151 9.3005
R740 w_80_n3360.n180 w_80_n3360.n148 9.3005
R741 w_80_n3360.n181 w_80_n3360.n145 9.3005
R742 w_80_n3360.n182 w_80_n3360.n142 9.3005
R743 w_80_n3360.n183 w_80_n3360.n139 9.3005
R744 w_80_n3360.n184 w_80_n3360.n136 9.3005
R745 w_80_n3360.n185 w_80_n3360.n133 9.3005
R746 w_80_n3360.n186 w_80_n3360.n131 9.3005
R747 w_80_n3360.n187 w_80_n3360.n128 9.3005
R748 w_80_n3360.n188 w_80_n3360.n125 9.3005
R749 w_80_n3360.n189 w_80_n3360.n122 9.3005
R750 w_80_n3360.n190 w_80_n3360.n119 9.3005
R751 w_80_n3360.n191 w_80_n3360.n116 9.3005
R752 w_80_n3360.n192 w_80_n3360.n113 9.3005
R753 w_80_n3360.n193 w_80_n3360.n110 9.3005
R754 w_80_n3360.n194 w_80_n3360.n107 9.3005
R755 w_80_n3360.n195 w_80_n3360.n104 9.3005
R756 w_80_n3360.n196 w_80_n3360.n101 9.3005
R757 w_80_n3360.n197 w_80_n3360.n98 9.3005
R758 w_80_n3360.n198 w_80_n3360.n95 9.3005
R759 w_80_n3360.n199 w_80_n3360.n92 9.3005
R760 w_80_n3360.n200 w_80_n3360.n89 9.3005
R761 w_80_n3360.n201 w_80_n3360.n86 9.3005
R762 w_80_n3360.n202 w_80_n3360.n83 9.3005
R763 w_80_n3360.n203 w_80_n3360.n80 9.3005
R764 w_80_n3360.n204 w_80_n3360.n77 9.3005
R765 w_80_n3360.n205 w_80_n3360.n74 9.3005
R766 w_80_n3360.n206 w_80_n3360.n71 9.3005
R767 w_80_n3360.n207 w_80_n3360.n68 9.3005
R768 w_80_n3360.n208 w_80_n3360.n65 9.3005
R769 w_80_n3360.n209 w_80_n3360.n62 9.3005
R770 w_80_n3360.n210 w_80_n3360.n59 9.3005
R771 w_80_n3360.n211 w_80_n3360.n56 9.3005
R772 w_80_n3360.n212 w_80_n3360.n54 9.3005
R773 w_80_n3360.n213 w_80_n3360.n51 9.3005
R774 w_80_n3360.n214 w_80_n3360.n48 9.3005
R775 w_80_n3360.n215 w_80_n3360.n45 9.3005
R776 w_80_n3360.n216 w_80_n3360.n42 9.3005
R777 w_80_n3360.n217 w_80_n3360.n39 9.3005
R778 w_80_n3360.n218 w_80_n3360.n36 9.3005
R779 w_80_n3360.n219 w_80_n3360.n33 9.3005
R780 w_80_n3360.n220 w_80_n3360.n30 9.3005
R781 w_80_n3360.n221 w_80_n3360.n27 9.3005
R782 w_80_n3360.n222 w_80_n3360.n24 9.3005
R783 w_80_n3360.n223 w_80_n3360.n21 9.3005
R784 w_80_n3360.n224 w_80_n3360.n18 9.3005
R785 w_80_n3360.n225 w_80_n3360.n15 9.3005
R786 w_80_n3360.n226 w_80_n3360.n12 9.3005
R787 w_80_n3360.n227 w_80_n3360.n9 9.3005
R788 w_80_n3360.n228 w_80_n3360.n6 9.3005
R789 w_80_n3360.n172 w_80_n3360.n3 4.28224
R790 w_80_n3360.n171 w_80_n3360.n173 589.355
R791 w_80_n3360.n169 w_80_n3360.n166 16.0005
R792 w_80_n3360.n166 w_80_n3360.n163 16.0005
R793 w_80_n3360.n163 w_80_n3360.n160 16.0005
R794 w_80_n3360.n160 w_80_n3360.n157 16.0005
R795 w_80_n3360.n157 w_80_n3360.n154 16.0005
R796 w_80_n3360.n154 w_80_n3360.n151 16.0005
R797 w_80_n3360.n151 w_80_n3360.n148 16.0005
R798 w_80_n3360.n148 w_80_n3360.n145 16.0005
R799 w_80_n3360.n145 w_80_n3360.n142 16.0005
R800 w_80_n3360.n142 w_80_n3360.n139 16.0005
R801 w_80_n3360.n139 w_80_n3360.n136 16.0005
R802 w_80_n3360.n136 w_80_n3360.n133 16.0005
R803 w_80_n3360.n133 w_80_n3360.n131 16.0005
R804 w_80_n3360.n131 w_80_n3360.n128 16.0005
R805 w_80_n3360.n128 w_80_n3360.n125 16.0005
R806 w_80_n3360.n125 w_80_n3360.n122 16.0005
R807 w_80_n3360.n122 w_80_n3360.n119 16.0005
R808 w_80_n3360.n119 w_80_n3360.n116 16.0005
R809 w_80_n3360.n116 w_80_n3360.n113 16.0005
R810 w_80_n3360.n113 w_80_n3360.n110 16.0005
R811 w_80_n3360.n110 w_80_n3360.n107 16.0005
R812 w_80_n3360.n107 w_80_n3360.n104 16.0005
R813 w_80_n3360.n104 w_80_n3360.n101 16.0005
R814 w_80_n3360.n101 w_80_n3360.n98 16.0005
R815 w_80_n3360.n98 w_80_n3360.n95 16.0005
R816 w_80_n3360.n95 w_80_n3360.n92 16.0005
R817 w_80_n3360.n92 w_80_n3360.n89 16.0005
R818 w_80_n3360.n89 w_80_n3360.n86 16.0005
R819 w_80_n3360.n86 w_80_n3360.n83 16.0005
R820 w_80_n3360.n83 w_80_n3360.n80 16.0005
R821 w_80_n3360.n80 w_80_n3360.n77 16.0005
R822 w_80_n3360.n77 w_80_n3360.n74 16.0005
R823 w_80_n3360.n74 w_80_n3360.n71 16.0005
R824 w_80_n3360.n71 w_80_n3360.n68 16.0005
R825 w_80_n3360.n68 w_80_n3360.n65 16.0005
R826 w_80_n3360.n65 w_80_n3360.n62 16.0005
R827 w_80_n3360.n62 w_80_n3360.n59 16.0005
R828 w_80_n3360.n59 w_80_n3360.n56 16.0005
R829 w_80_n3360.n56 w_80_n3360.n54 16.0005
R830 w_80_n3360.n54 w_80_n3360.n51 16.0005
R831 w_80_n3360.n51 w_80_n3360.n48 16.0005
R832 w_80_n3360.n48 w_80_n3360.n45 16.0005
R833 w_80_n3360.n45 w_80_n3360.n42 16.0005
R834 w_80_n3360.n42 w_80_n3360.n39 16.0005
R835 w_80_n3360.n39 w_80_n3360.n36 16.0005
R836 w_80_n3360.n36 w_80_n3360.n33 16.0005
R837 w_80_n3360.n33 w_80_n3360.n30 16.0005
R838 w_80_n3360.n30 w_80_n3360.n27 16.0005
R839 w_80_n3360.n27 w_80_n3360.n24 16.0005
R840 w_80_n3360.n24 w_80_n3360.n21 16.0005
R841 w_80_n3360.n21 w_80_n3360.n18 16.0005
R842 w_80_n3360.n18 w_80_n3360.n15 16.0005
R843 w_80_n3360.n15 w_80_n3360.n12 16.0005
R844 w_80_n3360.n12 w_80_n3360.n9 16.0005
R845 w_80_n3360.n9 w_80_n3360.n6 16.0005
R846 w_80_n3360.n6 w_80_n3360.n3 16.0005
R847 w_80_n3360.n173 w_80_n3360.n174 2.68753
R848 w_80_n3360.n174 w_80_n3360.n175 0.15675
R849 w_80_n3360.n175 w_80_n3360.n176 0.15675
R850 w_80_n3360.n176 w_80_n3360.n177 0.15675
R851 w_80_n3360.n177 w_80_n3360.n178 0.15675
R852 w_80_n3360.n178 w_80_n3360.n179 0.15675
R853 w_80_n3360.n179 w_80_n3360.n180 0.15675
R854 w_80_n3360.n180 w_80_n3360.n181 0.15675
R855 w_80_n3360.n181 w_80_n3360.n182 0.15675
R856 w_80_n3360.n182 w_80_n3360.n183 0.15675
R857 w_80_n3360.n183 w_80_n3360.n184 0.15675
R858 w_80_n3360.n184 w_80_n3360.n185 0.15675
R859 w_80_n3360.n185 w_80_n3360.n186 0.15675
R860 w_80_n3360.n186 w_80_n3360.n187 0.15675
R861 w_80_n3360.n187 w_80_n3360.n188 0.15675
R862 w_80_n3360.n188 w_80_n3360.n189 0.15675
R863 w_80_n3360.n189 w_80_n3360.n190 0.15675
R864 w_80_n3360.n190 w_80_n3360.n191 0.15675
R865 w_80_n3360.n191 w_80_n3360.n192 0.15675
R866 w_80_n3360.n192 w_80_n3360.n193 0.15675
R867 w_80_n3360.n193 w_80_n3360.n194 0.15675
R868 w_80_n3360.n194 w_80_n3360.n195 0.15675
R869 w_80_n3360.n195 w_80_n3360.n196 0.15675
R870 w_80_n3360.n196 w_80_n3360.n197 0.15675
R871 w_80_n3360.n197 w_80_n3360.n198 0.15675
R872 w_80_n3360.n198 w_80_n3360.n199 0.15675
R873 w_80_n3360.n199 w_80_n3360.n200 0.15675
R874 w_80_n3360.n200 w_80_n3360.n201 0.15675
R875 w_80_n3360.n201 w_80_n3360.n202 0.15675
R876 w_80_n3360.n202 w_80_n3360.n203 0.15675
R877 w_80_n3360.n203 w_80_n3360.n204 0.15675
R878 w_80_n3360.n204 w_80_n3360.n205 0.15675
R879 w_80_n3360.n205 w_80_n3360.n206 0.15675
R880 w_80_n3360.n206 w_80_n3360.n207 0.15675
R881 w_80_n3360.n207 w_80_n3360.n208 0.15675
R882 w_80_n3360.n208 w_80_n3360.n209 0.15675
R883 w_80_n3360.n209 w_80_n3360.n210 0.15675
R884 w_80_n3360.n210 w_80_n3360.n211 0.15675
R885 w_80_n3360.n211 w_80_n3360.n212 0.15675
R886 w_80_n3360.n212 w_80_n3360.n213 0.15675
R887 w_80_n3360.n213 w_80_n3360.n214 0.15675
R888 w_80_n3360.n214 w_80_n3360.n215 0.15675
R889 w_80_n3360.n215 w_80_n3360.n216 0.15675
R890 w_80_n3360.n216 w_80_n3360.n217 0.15675
R891 w_80_n3360.n217 w_80_n3360.n218 0.15675
R892 w_80_n3360.n218 w_80_n3360.n219 0.15675
R893 w_80_n3360.n219 w_80_n3360.n220 0.15675
R894 w_80_n3360.n220 w_80_n3360.n221 0.15675
R895 w_80_n3360.n221 w_80_n3360.n222 0.15675
R896 w_80_n3360.n222 w_80_n3360.n223 0.15675
R897 w_80_n3360.n223 w_80_n3360.n230 0.1255
R898 w_80_n3360.n230 w_80_n3360.n224 0.03175
R899 w_80_n3360.n224 w_80_n3360.n225 0.15675
R900 w_80_n3360.n225 w_80_n3360.n226 0.15675
R901 w_80_n3360.n226 w_80_n3360.n227 0.15675
R902 w_80_n3360.n227 w_80_n3360.n228 0.15675
R903 w_80_n3360.n228 w_80_n3360.n172 2.68753
R904 w_80_n3360.n230 w_80_n3360.n229 14.5144
R905 w_80_n3360.n229 w_80_n3360.t2 7.838
R906 w_80_n3360.n229 w_80_n3360.t4 7.838
R907 w_80_n3360.n171 w_80_n3360.n168 191
R908 w_80_n3360.n168 w_80_n3360.n165 191
R909 w_80_n3360.n165 w_80_n3360.n162 191
R910 w_80_n3360.n162 w_80_n3360.n159 191
R911 w_80_n3360.n159 w_80_n3360.n156 191
R912 w_80_n3360.n156 w_80_n3360.n153 191
R913 w_80_n3360.n153 w_80_n3360.n150 191
R914 w_80_n3360.n150 w_80_n3360.n147 191
R915 w_80_n3360.n147 w_80_n3360.n144 191
R916 w_80_n3360.n144 w_80_n3360.n141 191
R917 w_80_n3360.n141 w_80_n3360.n138 191
R918 w_80_n3360.n138 w_80_n3360.n135 191
R919 w_80_n3360.n135 w_80_n3360.n132 191
R920 w_80_n3360.n132 w_80_n3360.n130 191
R921 w_80_n3360.n130 w_80_n3360.n127 191
R922 w_80_n3360.n127 w_80_n3360.n124 191
R923 w_80_n3360.n124 w_80_n3360.n121 191
R924 w_80_n3360.n121 w_80_n3360.n118 191
R925 w_80_n3360.n118 w_80_n3360.n115 191
R926 w_80_n3360.n115 w_80_n3360.n112 191
R927 w_80_n3360.n112 w_80_n3360.n109 191
R928 w_80_n3360.n109 w_80_n3360.n106 191
R929 w_80_n3360.n106 w_80_n3360.n103 191
R930 w_80_n3360.n103 w_80_n3360.n100 191
R931 w_80_n3360.n100 w_80_n3360.n97 191
R932 w_80_n3360.n97 w_80_n3360.n94 191
R933 w_80_n3360.n94 w_80_n3360.n91 191
R934 w_80_n3360.n91 w_80_n3360.n88 191
R935 w_80_n3360.n88 w_80_n3360.n85 191
R936 w_80_n3360.n85 w_80_n3360.n82 191
R937 w_80_n3360.n82 w_80_n3360.n79 191
R938 w_80_n3360.n79 w_80_n3360.n76 191
R939 w_80_n3360.n76 w_80_n3360.n73 191
R940 w_80_n3360.n73 w_80_n3360.n70 191
R941 w_80_n3360.n70 w_80_n3360.n67 191
R942 w_80_n3360.n67 w_80_n3360.n64 191
R943 w_80_n3360.n64 w_80_n3360.n61 191
R944 w_80_n3360.n61 w_80_n3360.n58 191
R945 w_80_n3360.n58 w_80_n3360.n55 191
R946 w_80_n3360.n55 w_80_n3360.n53 191
R947 w_80_n3360.n53 w_80_n3360.n50 191
R948 w_80_n3360.n50 w_80_n3360.n47 191
R949 w_80_n3360.n47 w_80_n3360.n44 191
R950 w_80_n3360.n44 w_80_n3360.n41 191
R951 w_80_n3360.n41 w_80_n3360.n38 191
R952 w_80_n3360.n38 w_80_n3360.n35 191
R953 w_80_n3360.n35 w_80_n3360.n32 191
R954 w_80_n3360.n32 w_80_n3360.n29 191
R955 w_80_n3360.n29 w_80_n3360.n26 191
R956 w_80_n3360.n26 w_80_n3360.n23 191
R957 w_80_n3360.n23 w_80_n3360.n20 191
R958 w_80_n3360.n20 w_80_n3360.n17 191
R959 w_80_n3360.n17 w_80_n3360.n14 191
R960 w_80_n3360.n14 w_80_n3360.n11 191
R961 w_80_n3360.n11 w_80_n3360.n8 191
R962 w_80_n3360.n8 w_80_n3360.n5 191
R963 w_80_n3360.n5 w_80_n3360.n2 191
R964 w_80_n3360.n1 w_80_n3360.n172 679.909
C0 b1 sgn 0.08928f
C1 a1 nsum 0.67474f
C2 a1 b0 0.10027f
C3 nmir iout_n 0.4404f
C4 sgnb sgn 0.07178f
C5 vg4 vcasc 1.29382f
C6 vg vdd 4.19356f
C7 nsum sgn 0.35191f
C8 nsum b1 0.74796f
C9 b1 b0 0.06096f
C10 nsum a0 0.21854f
C11 sgnb nsum 0.21707f
C12 vg vg4 0.14842f
C13 nsum b0 0.3564f
C14 vg vcasc 1.81139f
C15 iout_p sgn 0.34329f
C16 iout_p b1 0.01238f
C17 nmir sgnb 0.40054f
C18 vg4 vdd 4.3236f
C19 vcasc vdd 5.46714f
C20 nmir nsum 0.30536f
C21 a1 a0 0.06918f
C22 nsum iout_p 0.3224f
C23 iout_n 0 1.22976f
C24 iout_p 0 0.74145f
C25 nsum 0 2.2974f
C26 nmir 0 4.80791f
C27 sgnb 0 0.50995f
C28 sgn 0 0.51192f
C29 b1 0 0.93803f
C30 b0 0 0.52051f
C31 a1 0 1.08526f
C32 a0 0 0.61153f
C33 vg4 0 0.72367f
C34 vg 0 0.61843f
C35 vcasc 0 1.05818f
C36 vdd 0 71.42337f
C37 vdd.t7 0 0.05468f
C38 vdd.n0 0 0.11652f
C39 vdd.n1 0 0.02855f
C40 vdd.n4 0 0.01794f
C41 vdd.n72 0 0.11652f
C42 vdd.t11 0 0.05468f
C43 vdd.t17 0 0.05468f
C44 vdd.n73 0 0.17242f
C45 vdd.n141 0 0.01794f
C46 vdd.n143 0 0.02855f
C47 vdd.n144 0 0.25497f
C48 vdd.n146 0 0.10867f
C49 vdd.n148 0 0.19758f
C50 vdd.n150 0 0.19758f
C51 vdd.n152 0 0.19758f
C52 vdd.n154 0 0.19758f
C53 vdd.n156 0 0.10867f
C54 vdd.n158 0 0.1877f
C55 vdd.n160 0 0.19758f
C56 vdd.n162 0 0.19758f
C57 vdd.n164 0 0.19758f
C58 vdd.n166 0 0.19758f
C59 vdd.n168 0 0.12843f
C60 vdd.n170 0 0.16794f
C61 vdd.n172 0 0.19758f
C62 vdd.n174 0 0.19758f
C63 vdd.n176 0 0.19758f
C64 vdd.n178 0 0.14818f
C65 vdd.n180 0 0.14818f
C66 vdd.n182 0 0.19758f
C67 vdd.n184 0 0.19758f
C68 vdd.n186 0 0.19758f
C69 vdd.n188 0 0.19758f
C70 vdd.n190 0 0.19758f
C71 vdd.n192 0 0.19758f
C72 vdd.n194 0 0.19758f
C73 vdd.n196 0 0.16794f
C74 vdd.n198 0 0.12843f
C75 vdd.n200 0 0.19758f
C76 vdd.n202 0 0.19758f
C77 vdd.n204 0 0.19758f
C78 vdd.n206 0 0.1877f
C79 vdd.n208 0 0.10867f
C80 vdd.n210 0 0.19758f
C81 vdd.n212 0 0.19758f
C82 vdd.n214 0 0.19758f
C83 vdd.n216 0 0.19758f
C84 vdd.n218 0 0.19758f
C85 vdd.n220 0 0.10867f
C86 vdd.n222 0 0.1877f
C87 vdd.n224 0 0.19758f
C88 vdd.n226 0 0.19758f
C89 vdd.n228 0 0.19758f
C90 vdd.n230 0 0.12843f
C91 vdd.n232 0 0.16794f
C92 vdd.n234 0 0.19758f
C93 vdd.n236 0 0.19758f
C94 vdd.n238 0 0.19758f
C95 vdd.n240 0 0.19758f
C96 vdd.n242 0 0.19758f
C97 vdd.n244 0 0.19758f
C98 vdd.n246 0 0.19758f
C99 vdd.n248 0 0.14818f
C100 vdd.n250 0 0.14818f
C101 vdd.n252 0 0.19758f
C102 vdd.n254 0 0.19758f
C103 vdd.n256 0 0.19758f
C104 vdd.n258 0 0.16794f
C105 vdd.n260 0 0.12843f
C106 vdd.n262 0 0.19758f
C107 vdd.n264 0 0.19758f
C108 vdd.n266 0 0.19758f
C109 vdd.n268 0 0.19758f
C110 vdd.n270 0 0.1877f
C111 vdd.n272 0 0.10867f
C112 vdd.n274 0 0.19758f
C113 vdd.n276 0 0.19758f
C114 vdd.n278 0 0.19758f
C115 vdd.n280 0 0.19758f
C116 vdd.n282 0 0.10867f
C117 vdd.n284 0 0.25497f
C118 vdd.t0 0 0.61678f
C119 vdd.t6 0 0.09879f
C120 vdd.t8 0 0.09879f
C121 vdd.t1 0 0.09879f
C122 vdd.t2 0 0.09879f
C123 vdd.t10 0 0.09879f
C124 vdd.t16 0 0.09879f
C125 vdd.t3 0 0.09879f
C126 vdd.t4 0 0.09879f
C127 vdd.t14 0 0.09879f
C128 vdd.t12 0 0.09879f
C129 vdd.t5 0 0.61678f
C130 vdd.n286 0 0.11645f
C131 vdd.t15 0 0.05468f
C132 vdd.t13 0 0.05468f
C133 vdd.n288 0 0.16993f
C134 vdd.t9 0 0.05468f
C135 a_200_n2000.t1 0 0.58585f
C136 a_200_n2000.t0 0 0.75039f
C137 a_620_600.t0 0 0.66749f
C138 a_620_600.t1 0 0.66749f
C139 a_1860_600.t0 0 0.66865f
C140 a_1860_600.t1 0 0.66865f
C141 a_840_n2000.t1 0 1.36521f
C142 a_840_n2000.t0 0 1.65273f
C143 a_1340_n2000.t1 0 1.5728f
C144 a_1340_n2000.t0 0 1.89759f
C145 a_3200_600.t0 0 0.67145f
C146 a_3200_600.t1 0 0.67145f
C147 a_4440_600.t0 0 0.67055f
C148 a_4440_600.t1 0 0.67055f
C149 a_1980_n2000.t1 0 1.89979f
C150 a_1980_n2000.t0 0 2.19236f
C151 a_2480_n2000.t1 0 2.05315f
C152 a_2480_n2000.t0 0 2.36154f
C153 a_5780_600.t0 0 0.6704f
C154 a_5780_600.t1 0 0.6704f
C155 a_7020_600.t0 0 0.6704f
C156 a_7020_600.t1 0 0.6704f
C157 a_3120_n2000.t1 0 1.36358f
C158 a_3120_n2000.t0 0 1.51203f
C159 nmir.t2 0 0.0982f
C160 nmir.t1 0 0.15355f
C161 nmir.t3 0 0.28071f
C162 nmir.t0 0 0.28046f
C163 nmir.n0 0 0.14518f
C164 nsum.t0 0 0.13279f
C165 nsum.n0 0 0.37972f
C166 nsum.n1 0 0.34302f
C167 nsum.t5 0 0.13279f
C168 nsum.t6 0 0.13279f
C169 nsum.n2 0 0.37972f
C170 nsum.t3 0 0.13279f
C171 nsum.t4 0 0.13279f
C172 nsum.n3 0 1.14311f
C173 nsum.n4 0 0.38878f
C174 nsum.t2 0 0.13279f
C175 nsum.t1 0 0.13279f
C176 nsum.n5 0 0.76939f
C177 nsum.t7 0 0.13279f
C178 iout_p.t0 0 0.34939f
C179 iout_n.t0 0 0.19921f
.ends
