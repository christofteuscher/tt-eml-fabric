* Whole-cell temperature baseline (uncompensated, ideal biases fixed).
.lib $PDK_ROOT/sky130A/libs.tech/ngspice/sky130.lib.spice tt
.include v2d_core.inc
.control
set filetype=ascii
echo > v2d_temp.txt
foreach t -20 0 27 55 85
  option temp = $t
  alter IUIN = 0
  alter IV = 0.5u
  op
  let p1 = i(vout)
  set pp1 = $&p1
  alter IUIN = -1u
  op
  let p2 = i(vout)
  set pp2 = $&p2
  alter IUIN = 0
  alter IV = 2.5u
  op
  let p3 = i(vout)
  set pp3 = $&p3
  echo $t $pp1 $pp2 $pp3 >> v2d_temp.txt
end
echo TEMP_DONE
.endc
.end
