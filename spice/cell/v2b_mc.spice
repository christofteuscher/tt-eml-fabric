* Whole-cell Monte Carlo: v2b with mismatch models (tt_mm).
* 3 op points per sample: (u=0,v=1) offset, (u=2,v=1) exp, (u=0,v=5) ln.
.lib $PDK_ROOT/sky130A/libs.tech/ngspice/sky130.lib.spice tt_mm
.include v2b_core.inc
.control
set filetype=ascii
echo > v2b_mc.txt
let idx = 0
dowhile idx < 60
  reset
  alter IUIN = 0
  alter IV = 0.5u
  op
  let p1 = i(vout)
  set pp1 = $&p1
  alter IUIN = -1u
  op
  let p2 = i(vout)
  set pp2 = $&p2
  alter IUIN = 0
  alter IV = 2.5u
  op
  let p3 = i(vout)
  set pp3 = $&p3
  echo $pp1 $pp2 $pp3 >> v2b_mc.txt
  let idx = idx + 1
end
echo MC_DONE
.endc
.end
