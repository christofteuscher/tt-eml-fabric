* v3 power-up transient at corner v_eff points; rails ramp 1u->6u.
.lib $PDK_ROOT/sky130A/libs.tech/ngspice/sky130.lib.spice tt
.param ivin=0.5u
VDD vdd 0 PWL(0 0 1u 0 6u 3.3)
VRB vrefb 0 PWL(0 0 1u 0 6u 1.2)
VE  ve 0 PWL(0 0 1u 0 6u 0.55)
IUIN 0 nu 0
IVIN 0 nv {ivin}
XCELL nu nv out vdd vrefb ve emlcell
VOUT out 0 0.9
.include eml_cell_v3.inc
.control
set filetype=ascii
echo > v3_tran_results.txt
foreach iv -0.5u 0.5u 15u
  alterparam ivin = $iv
  reset
  tran 0.05u 150u
  let tail = i(VOUT)[length(i(VOUT))-1]
  meas tran vmean AVG i(VOUT) from=120u to=150u
  meas tran vmax MAX i(VOUT) from=120u to=150u
  meas tran vmin MIN i(VOUT) from=120u to=150u
  echo $iv $&vmean $&vmax $&vmin >> v3_tran_results.txt
  destroy all
end
echo TRAN_DONE
.endc
.end
