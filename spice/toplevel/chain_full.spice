* GENERATED by gen_chain.py -- full-silicon beta-model thermistor chain
* ======================================================================
* THIS DECK DOES NOT MODEL THE CHIP THAT SHIPPED (marked 2026-08-16).
* Its result -- "out_C = +0.419 - 0.059*ln(x), residual 0.0027 units rms
* (1.1 % of span)", quoted in STATUS.md 3 and in tt-eml-fabric
* docs/info.md -- is UNVALIDATED for the fabricated part.
*
* WORSE: THIS DECK NO LONGER RUNS.  Measured 2026-08-16, ngspice -b:
*     Too many parameters for subcircuit type "raildrv" (instance: xxrd)
*     Simulation interrupted due to error!
* XRD below passes SIX nodes (vdd pbias nd12 nd055 vrefb ve) to a
* raildrv that bias/ptat_bias.inc:106 declares with FOUR
* (.subckt raildrv ve nd055 vdd pbias).  The note at the top of this file
* records the SAME failure happening once already, when ptatbias grew
* from 4 pins to 8.  It happened again to raildrv and nothing caught it,
* because nothing runs this deck.  The quoted figure therefore has no
* reproducible source on this tree.
*
* And fixing the pin list would still not validate the shipped part:
*   1. THREE cells (XCA/XCB/XCC).  The die has TWO: 3 cells fails
*      placement (STATUS.md 2).
*   2. The couplings below are hand-sized, geometry-ratioed mirror legs
*      (XGOGB W=4.192, XPAB W=11.942, ...) -- continuous and exact.  The
*      die's couplings are 4-bit signed radix-4 MDACs: 16 levels, LSB
*      1/4 unit, full scale 3.75 units.  Quantisation is not modelled
*      here AT ALL.
*   3. The mdac include below is mdac_weight.inc, the 3-DIGIT THERMOMETER
*      part (and it is pulled in only for mdac_div inside ptat_bias).
*      The silicon is mdac_weight_d2.inc, 2-DIGIT BINARY.
* Re-running this deck re-measures the same non-shipped circuit; it
* cannot validate the shipped one.  That needs a NEW deck: 2 cells and
* quantised MDAC weights.  Until it exists, do not quote the figure as a
* result for this chip.
* ======================================================================
.lib /Users/cteusche/.ciel/sky130A/libs.tech/ngspice/sky130.lib.spice tt

VDD vdd 0 3.3
* ptatbias grew from 4 pins to 8 when the rail divider and the shared MDAC
* reference chain moved into it; this deck still called the old 4-pin
* version, so the chain has not actually been simulated since that rework.
* vrefb/ve now come from raildrv, which buffers the divider taps.
XBIAS vdd pbias nd12 nd055 vcasc vgu vg4 vg16 ptatbias
XRD   vdd pbias nd12 nd055 vrefb ve raildrv
XLMON nmon pbias vdd vdd sky130_fd_pr__pfet_g5v0d10v5 W=4 L=8
VMON nmon 0 1.0

* bench input: x as current into cell A's v-node (beta_A = 1 direct)
IX 0 nva_in 0.5u

* ---- cells ----
XCA nua nva_in outa vdd vrefb ve pbias emlcell_b
XCB nub nvb_in outb vdd vrefb ve pbias emlcell_b
XCC nuc nvc_in outc vdd vrefb ve pbias emlcell_b
VOUTC outc 0 0.9

XPUA nua pbias vdd vdd sky130_fd_pr__pfet_g5v0d10v5 W=24.000 L=8
XPSAV fAV pbias vdd vdd sky130_fd_pr__pfet_g5v0d10v5 W=8.000 L=8
VSPAV fAV ndAV 0
XN1AV ndAV ndAV 0 0 sky130_fd_pr__nfet_g5v0d10v5 W=16 L=2
XN2AV oAV ndAV 0 0 sky130_fd_pr__nfet_g5v0d10v5 W=16 L=2
VSNAV nva_in oAV 0
XPOA outa pbias vdd vdd sky130_fd_pr__pfet_g5v0d10v5 W=24.000 L=8
XPUB nub pbias vdd vdd sky130_fd_pr__pfet_g5v0d10v5 W=24.000 L=8
VSDGB outa outad 0
XGDGB outad outad 0 0 sky130_fd_pr__nfet_g5v0d10v5 W=16 L=2
XGOGB nvb_in outad 0 0 sky130_fd_pr__nfet_g5v0d10v5 W=4.192 L=2
XPAB nvb_in pbias vdd vdd sky130_fd_pr__pfet_g5v0d10v5 W=11.942 L=8
XPOB outb pbias vdd vdd sky130_fd_pr__pfet_g5v0d10v5 W=24.000 L=8
VSDGC outb outbd 0
XGDGC outbd outbd 0 0 sky130_fd_pr__nfet_g5v0d10v5 W=16 L=2
XGOGC nuc outbd 0 0 sky130_fd_pr__nfet_g5v0d10v5 W=16.000 L=2
XPUC nuc pbias vdd vdd sky130_fd_pr__pfet_g5v0d10v5 W=24.000 L=8
XPAC nvc_in pbias vdd vdd sky130_fd_pr__pfet_g5v0d10v5 W=4.000 L=8
XPOC outc pbias vdd vdd sky130_fd_pr__pfet_g5v0d10v5 W=24.000 L=8

.include /Users/cteusche/data/projects/eml/code/silicon/cell/v3/eml_cell_v3.inc
.include /Users/cteusche/data/projects/eml/code/silicon/cell/v3/eml_cell_v3b.inc
.include /Users/cteusche/data/projects/eml/code/silicon/bias/ptat_bias.inc
* ptat_bias instantiates mdac_div for the shared /4 and /16 reference
* gates, so the MDAC library has to come along.  Its absence is why this
* deck failed with "incomplete or empty netlist" -- pre-existing, not
* caused by the OTA shrink.
.include /Users/cteusche/data/projects/eml/code/silicon/mdac/mdac_weight.inc

.control
set filetype=ascii
* PRESCALE x2: IX = 2x*iu (centers ln window); sweep HIGH->LOW
* (low-x end is below pedestal floor; never START a sweep there)
dc IX 12.4u 0.15u -0.05u
wrdata chain_full.csv i(VOUTC) i(VMON) i(VSDGB) i(VSDGC) i(VSPAV) i(VSNAV) v(nva_in) v(ndAV)
echo CHAIN_DONE
.endc
.end
