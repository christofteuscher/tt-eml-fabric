* GENERATED by gen_chain.py -- full-silicon beta-model thermistor chain
.lib $PDK_ROOT/sky130A/libs.tech/ngspice/sky130.lib.spice tt

VDD vdd 0 3.3
XBIAS vdd pbias vrefb ve ptatbias
XLMON nmon pbias vdd vdd sky130_fd_pr__pfet_g5v0d10v5 W=4 L=8
VMON nmon 0 1.0

* bench input: x as current into cell A's v-node (beta_A = 1 direct)
IX 0 nva_in 0.5u

* ---- cells ----
XCA nua nva_in outa vdd vrefb ve pbias emlcell_b
XCB nub nvb_in outb vdd vrefb ve pbias emlcell_b
XCC nuc nvc_in outc vdd vrefb ve pbias emlcell_b
VOUTC outc 0 0.9

XPUA nua pbias vdd vdd sky130_fd_pr__pfet_g5v0d10v5 W=24.000 L=8
XPSAV fAV pbias vdd vdd sky130_fd_pr__pfet_g5v0d10v5 W=8.000 L=8
VSPAV fAV ndAV 0
XN1AV ndAV ndAV 0 0 sky130_fd_pr__nfet_g5v0d10v5 W=16 L=2
XN2AV oAV ndAV 0 0 sky130_fd_pr__nfet_g5v0d10v5 W=16 L=2
VSNAV nva_in oAV 0
XPOA outa pbias vdd vdd sky130_fd_pr__pfet_g5v0d10v5 W=24.000 L=8
XPUB nub pbias vdd vdd sky130_fd_pr__pfet_g5v0d10v5 W=24.000 L=8
VSDGB outa outad 0
XGDGB outad outad 0 0 sky130_fd_pr__nfet_g5v0d10v5 W=16 L=2
XGOGB nvb_in outad 0 0 sky130_fd_pr__nfet_g5v0d10v5 W=4.192 L=2
XPAB nvb_in pbias vdd vdd sky130_fd_pr__pfet_g5v0d10v5 W=11.942 L=8
XPOB outb pbias vdd vdd sky130_fd_pr__pfet_g5v0d10v5 W=24.000 L=8
VSDGC outb outbd 0
XGDGC outbd outbd 0 0 sky130_fd_pr__nfet_g5v0d10v5 W=16 L=2
XGOGC nuc outbd 0 0 sky130_fd_pr__nfet_g5v0d10v5 W=16.000 L=2
XPUC nuc pbias vdd vdd sky130_fd_pr__pfet_g5v0d10v5 W=24.000 L=8
XPAC nvc_in pbias vdd vdd sky130_fd_pr__pfet_g5v0d10v5 W=4.000 L=8
XPOC outc pbias vdd vdd sky130_fd_pr__pfet_g5v0d10v5 W=24.000 L=8

.include ../cell/v3/eml_cell_v3.inc
.include ../cell/v3/eml_cell_v3b.inc
.include ../bias/ptat_bias.inc

.control
set filetype=ascii
* PRESCALE x2: IX = 2x*iu (centers ln window); sweep HIGH->LOW
* (low-x end is below pedestal floor; never START a sweep there)
dc IX 12.4u 0.15u -0.05u
wrdata chain_full.csv i(VOUTC) i(VMON) i(VSDGB) i(VSDGC) i(VSPAV) i(VSNAV) v(nva_in) v(ndAV)
echo CHAIN_DONE
.endc
.end
