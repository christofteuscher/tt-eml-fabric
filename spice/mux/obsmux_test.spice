* obsmux verification: does the selected channel reach the pin intact, and
* do the other seven stay biased instead of floating?
* Channels are driven by cascoded PMOS copy legs (what a real mirror copy
* looks like) so compliance and Ron are exercised, not idealised.
.lib /Users/cteusche/.ciel/sky130A/libs.tech/ngspice/sky130.lib.spice tt
.include obsmux.inc

VDD vdd 0 3.3
VSS VSUB 0 0
* dump rail held at the same potential the SMU presents, so a dumped copy
* sees the same Vds as a selected one -- otherwise switching channels
* would shift every mirror
VDUMP dump 0 0.9
* SMU at virtual ground
VOUT nout 0 0.9
VSENSE nout mux_out 0

* eight distinct copy currents, 0.5 .. 4.0 uA, each through a cascode
.param ic=1u
I0 vdd c0 0.5u
I1 vdd c1 1.0u
I2 vdd c2 1.5u
I3 vdd c3 2.0u
I4 vdd c4 2.5u
I5 vdd c5 3.0u
I6 vdd c6 3.5u
I7 vdd c7 4.0u
.param vc=0.85
VC vcasc 0 'vc'
XC0 ch0 vcasc c0 vdd sky130_fd_pr__pfet_g5v0d10v5 W=8 L=1
XC1 ch1 vcasc c1 vdd sky130_fd_pr__pfet_g5v0d10v5 W=8 L=1
XC2 ch2 vcasc c2 vdd sky130_fd_pr__pfet_g5v0d10v5 W=8 L=1
XC3 ch3 vcasc c3 vdd sky130_fd_pr__pfet_g5v0d10v5 W=8 L=1
XC4 ch4 vcasc c4 vdd sky130_fd_pr__pfet_g5v0d10v5 W=8 L=1
XC5 ch5 vcasc c5 vdd sky130_fd_pr__pfet_g5v0d10v5 W=8 L=1
XC6 ch6 vcasc c6 vdd sky130_fd_pr__pfet_g5v0d10v5 W=8 L=1
XC7 ch7 vcasc c7 vdd sky130_fd_pr__pfet_g5v0d10v5 W=8 L=1

.param s0=0 s1=0 s2=0 s3=0 s4=0 s5=0 s6=0 s7=0
VH0 moh0 0 's0*3.3'
VH1 moh1 0 's1*3.3'
VH2 moh2 0 's2*3.3'
VH3 moh3 0 's3*3.3'
VH4 moh4 0 's4*3.3'
VH5 moh5 0 's5*3.3'
VH6 moh6 0 's6*3.3'
VH7 moh7 0 's7*3.3'
VB0 mohb0 0 '(1-s0)*3.3'
VB1 mohb1 0 '(1-s1)*3.3'
VB2 mohb2 0 '(1-s2)*3.3'
VB3 mohb3 0 '(1-s3)*3.3'
VB4 mohb4 0 '(1-s4)*3.3'
VB5 mohb5 0 '(1-s5)*3.3'
VB6 mohb6 0 '(1-s6)*3.3'
VB7 mohb7 0 '(1-s7)*3.3'

XMUX mux_out dump vdd VSUB ch0 ch1 ch2 ch3 ch4 ch5 ch6 ch7
+ moh0 moh1 moh2 moh3 moh4 moh5 moh6 moh7
+ mohb0 mohb1 mohb2 mohb3 mohb4 mohb5 mohb6 mohb7 obsmux

.control
set filetype=ascii
echo > obsmux.txt
* select each channel in turn; record what the pin sees
let k = 0
dowhile k < 8
  alterparam s0 = 0
  alterparam s1 = 0
  alterparam s2 = 0
  alterparam s3 = 0
  alterparam s4 = 0
  alterparam s5 = 0
  alterparam s6 = 0
  alterparam s7 = 0
  if k = 0
     alterparam s0 = 1
  end
  if k = 1
     alterparam s1 = 1
  end
  if k = 2
     alterparam s2 = 1
  end
  if k = 3
     alterparam s3 = 1
  end
  if k = 4
     alterparam s4 = 1
  end
  if k = 5
     alterparam s5 = 1
  end
  if k = 6
     alterparam s6 = 1
  end
  if k = 7
     alterparam s7 = 1
  end
  reset
  op
  echo $&k $&i(VSENSE) $&v(ch0) $&v(ch1) $&v(ch7) >> obsmux.txt
  let k = k + 1
end
echo MUX_DONE
.endc
.end
