* S/H switch off-leakage, tt 27C (schematic devices, no layout): Vgs=0, Vds=1 V
.lib $PDK_ROOT/sky130A/libs.tech/ngspice/sky130.lib.spice tt
.temp 27
VD1 d1 0 1
VA1 d1 dd1 0
XN1 dd1 0 0 0 sky130_fd_pr__nfet_01v8 W=0.42 L=0.15
VD2 d2 0 1
VA2 d2 dd2 0
XN2 dd2 0 0 0 sky130_fd_pr__nfet_g5v0d10v5 W=0.42 L=0.5
VD3 d3 0 1
VA3 d3 dd3 0
XN3 dd3 0 0 0 sky130_fd_pr__nfet_01v8_lvt W=0.42 L=0.15
.control
op
print i(VA1) i(VA2) i(VA3)
.endc
.end
