* NGSPICE file created from emlcell_b.ext - technology: sky130A

.subckt emlcell_b
X0 a_16237_18364.t1 a_15733_18364.t1 VSUB.t5 sky130_fd_pr__res_high_po_0p35 l=11.44
X1 VSUB.t22 a_13460_550.t2 a_13460_550.t3 VSUB.t21 sky130_fd_pr__nfet_g5v0d10v5 ad=2.2 pd=5.1 as=4.4 ps=10.2 w=4 l=2
X2 vdd.t13 pbias out.t2 vdd.t12 sky130_fd_pr__pfet_g5v0d10v5 ad=9.6 pd=33.2 as=9.6 ps=33.2 w=16 l=8
X3 a_14221_18364.t1 a_13717_18364.t1 VSUB.t5 sky130_fd_pr__res_high_po_0p35 l=11.44
X4 ve.t2 a_4860_8760.t2 a_4860_8760.t3 VSUB.t18 sky130_fd_pr__nfet_g5v0d10v5 ad=2.2 pd=5.1 as=4.4 ps=10.2 w=4 l=2
X5 a_13717_18364.t0 nu.t0 VSUB.t5 sky130_fd_pr__res_high_po_0p35 l=11.44
X6 a_16741_18364.t1 a_16237_18364.t0 VSUB.t5 sky130_fd_pr__res_high_po_0p35 l=11.44
X7 a_5880_10660.t2 dw_12460_11350.t5 a_4860_8760.t1 vdd.t8 sky130_fd_pr__pfet_g5v0d10v5 ad=8.8 pd=17.1 as=8.8 ps=17.1 w=16 l=2
X8 a_2374_3250.t4 nb0 a_1840_1350.t3 vdd.t40 sky130_fd_pr__pfet_g5v0d10v5 ad=17.6 pd=34.2 as=8.8 ps=17.1 w=16 l=2
X9 vdd.t26 pbias nb0 vdd.t25 sky130_fd_pr__pfet_g5v0d10v5 ad=2.4 pd=9.2 as=2.4 ps=9.2 w=4 l=8
X10 w_9880_11630.t2 vrefb.t5 a_1400_10660.t1 vdd.t33 sky130_fd_pr__pfet_g5v0d10v5 ad=8.8 pd=17.1 as=8.8 ps=17.1 w=16 l=2
X11 a_4860_8760.t0 dw_12460_11350.t6 a_5880_10660.t1 vdd.t0 sky130_fd_pr__pfet_g5v0d10v5 ad=8.8 pd=17.1 as=8.8 ps=17.1 w=16 l=2
X12 vdd.t11 pbias nsv.t1 vdd.t10 sky130_fd_pr__pfet_g5v0d10v5 ad=9.6 pd=33.2 as=9.6 ps=33.2 w=16 l=8
X13 a_1400_10660.t3 nv.t4 a_380_8760.t1 vdd.t9 sky130_fd_pr__pfet_g5v0d10v5 ad=8.8 pd=17.1 as=8.8 ps=17.1 w=16 l=2
X14 a_14480_2450.t4 pbias vdd.t30 vdd.t29 sky130_fd_pr__pfet_g5v0d10v5 ad=8.8 pd=17.1 as=17.6 ps=34.2 w=16 l=4
X15 VSUB.t23 a_13100_15680.t1 sky130_fd_pr__cap_mim_m3_1 l=15.65 w=32
X16 VSUB.t7 a_1840_1350.t5 w_12740_8770.t0 VSUB.t6 sky130_fd_pr__nfet_g5v0d10v5 ad=4.4 pd=9.1 as=8.8 ps=18.2 w=8 l=1
X17 vdd.t15 pbias dw_12460_11350.t1 vdd.t14 sky130_fd_pr__pfet_g5v0d10v5 ad=4.8 pd=17.2 as=4.8 ps=17.2 w=8 l=8
X18 a_13460_550.t0 nsv.t4 a_14480_2450.t0 vdd.t6 sky130_fd_pr__pfet_g5v0d10v5 ad=8.8 pd=17.1 as=8.8 ps=17.1 w=16 l=2
X19 w_12740_8770.t1 a_1840_1350.t4 VSUB.t9 VSUB.t8 sky130_fd_pr__nfet_g5v0d10v5 ad=8.8 pd=18.2 as=4.4 ps=9.1 w=8 l=1
X20 ndl.t0 a_13100_15680.t4 nsv.t0 VSUB.t1 sky130_fd_pr__nfet_03v3_nvt ad=2.4 pd=9.2 as=2.4 ps=9.2 w=4 l=0.5
X21 w_12740_8770.t5 a_1840_1350.t1 sky130_fd_pr__cap_mim_m3_1 l=17.3 w=58
X22 w_9880_11630.t1 a_16741_18364.t0 VSUB.t5 sky130_fd_pr__res_high_po_0p35 l=11.44
X23 a_380_8760.t0 nv.t5 a_1400_10660.t0 vdd.t1 sky130_fd_pr__pfet_g5v0d10v5 ad=8.8 pd=17.1 as=8.8 ps=17.1 w=16 l=2
X24 a_5880_10660.t4 pbias vdd.t24 vdd.t23 sky130_fd_pr__pfet_g5v0d10v5 ad=8.8 pd=17.1 as=17.6 ps=34.2 w=16 l=4
X25 vdd.t5 nc2 nc2 vdd.t4 sky130_fd_pr__pfet_g5v0d10v5 ad=4.8 pd=17.2 as=4.8 ps=17.2 w=8 l=2
X26 nv w_9880_11630.t5 ve.t1 VSUB sky130_fd_pr__npn_05v5_W1p00L1p00
**devattr s=40000,800 d=2446096,6256
X27 nc2.t1 w_12740_8770.t6 VSUB.t0 VSUB sky130_fd_pr__npn_05v5_W1p00L1p00
**devattr s=40000,800 d=2446096,6256
X28 a_14725_18364.t1 a_14221_18364.t0 VSUB.t5 sky130_fd_pr__res_high_po_0p35 l=11.44
X29 a_13100_15680.t0 w_12740_11630.t5 a_14480_2450.t1 vdd.t37 sky130_fd_pr__pfet_g5v0d10v5 ad=8.8 pd=17.1 as=8.8 ps=17.1 w=16 l=2
X30 a_1840_1350.t0 a_600_1350.t4 VSUB.t12 VSUB.t10 sky130_fd_pr__nfet_g5v0d10v5 ad=4.4 pd=10.2 as=2.2 ps=5.1 w=4 l=2
X31 nb0.t1 nb0 VSUB.t17 VSUB sky130_fd_pr__npn_05v5_W1p00L1p00
**devattr s=40000,800 d=2446096,6256
X32 VSUB.t14 ndl.t1 ndl.t2 VSUB.t13 sky130_fd_pr__nfet_g5v0d10v5 ad=19.2 pd=65.2 as=19.2 ps=65.2 w=32 l=2
X33 a_14480_2450.t2 nsv.t3 a_13460_550.t1 vdd.t7 sky130_fd_pr__pfet_g5v0d10v5 ad=8.8 pd=17.1 as=8.8 ps=17.1 w=16 l=2
X34 VSUB.t11 a_600_1350.t2 a_600_1350.t3 VSUB.t10 sky130_fd_pr__nfet_g5v0d10v5 ad=2.2 pd=5.1 as=4.4 ps=10.2 w=4 l=2
X35 a_2374_3250.t2 pbias vdd.t28 vdd.t27 sky130_fd_pr__pfet_g5v0d10v5 ad=8.8 pd=17.1 as=8.8 ps=17.1 w=16 l=4
X36 dw_12460_11350# w_12740_11630.t6 ve.t0 VSUB sky130_fd_pr__npn_05v5_W1p00L1p00
**devattr s=40000,800 d=2446096,6256
X37 VSUB.t16 ndl.t3 out.t1 VSUB.t15 sky130_fd_pr__nfet_g5v0d10v5 ad=19.2 pd=65.2 as=19.2 ps=65.2 w=32 l=2
X38 vdd.t3 nc2 out.t0 vdd.t2 sky130_fd_pr__pfet_g5v0d10v5 ad=4.8 pd=17.2 as=4.8 ps=17.2 w=8 l=2
X39 w_12740_8770.t4 a_14725_18364.t0 VSUB.t5 sky130_fd_pr__res_high_po_0p35 l=11.44
X40 vrefb.t1 nv.t0 VSUB.t4 sky130_fd_pr__res_xhigh_po_0p35 l=17.5
X41 vrefb.t0 dw_12460_11350.t0 VSUB.t4 sky130_fd_pr__res_xhigh_po_0p35 l=17.5
X42 nu.t1 w_12740_8770.t3 sky130_fd_pr__cap_mim_m3_1 l=15.6 w=32
X43 w_9880_11630.t0 a_380_8760.t4 ve.t3 VSUB.t3 sky130_fd_pr__nfet_g5v0d10v5 ad=4.4 pd=10.2 as=2.2 ps=5.1 w=4 l=2
X44 a_14480_2450.t3 w_12740_11630.t4 a_13100_15680.t2 vdd.t38 sky130_fd_pr__pfet_g5v0d10v5 ad=17.6 pd=34.2 as=8.8 ps=17.1 w=16 l=2
X45 a_15733_18364.t0 nsv.t2 VSUB.t5 sky130_fd_pr__res_high_po_0p35 l=11.44
X46 w_12740_11630.t2 a_4860_8760.t4 ve.t5 VSUB.t18 sky130_fd_pr__nfet_g5v0d10v5 ad=4.4 pd=10.2 as=2.2 ps=5.1 w=4 l=2
X47 a_13100_15680.t3 a_13460_550.t4 VSUB.t20 VSUB.t19 sky130_fd_pr__nfet_g5v0d10v5 ad=4.4 pd=10.2 as=2.2 ps=5.1 w=4 l=2
X48 vdd.t20 pbias w_12740_8770.t2 vdd.t19 sky130_fd_pr__pfet_g5v0d10v5 ad=8.8 pd=17.1 as=17.6 ps=34.2 w=16 l=2.67
X49 w_12740_11630.t3 dw_12460_11350.t3 sky130_fd_pr__cap_mim_m3_1 l=15.65 w=32
X50 ve.t4 a_380_8760.t2 a_380_8760.t3 VSUB.t2 sky130_fd_pr__nfet_g5v0d10v5 ad=2.2 pd=5.1 as=4.4 ps=10.2 w=4 l=2
X51 a_1840_1350.t2 nb0 a_2374_3250.t3 vdd.t39 sky130_fd_pr__pfet_g5v0d10v5 ad=8.8 pd=17.1 as=8.8 ps=17.1 w=16 l=2
X52 vdd.t17 pbias dw_12460_11350.t2 vdd.t16 sky130_fd_pr__pfet_g5v0d10v5 ad=2.4 pd=9.2 as=2.4 ps=9.2 w=4 l=8
X53 a_600_1350.t1 nu.t3 a_2374_3250.t1 vdd.t31 sky130_fd_pr__pfet_g5v0d10v5 ad=8.8 pd=17.1 as=8.8 ps=17.1 w=16 l=2
X54 a_1400_10660.t4 pbias vdd.t22 vdd.t21 sky130_fd_pr__pfet_g5v0d10v5 ad=8.8 pd=17.1 as=17.6 ps=34.2 w=16 l=4
X55 a_2374_3250.t0 nu.t2 a_600_1350.t0 vdd.t32 sky130_fd_pr__pfet_g5v0d10v5 ad=8.8 pd=17.1 as=8.8 ps=17.1 w=16 l=2
X56 w_9880_11630.t4 nv.t1 sky130_fd_pr__cap_mim_m3_1 l=15.65 w=32
X57 vdd.t18 pbias nv.t3 vdd.t14 sky130_fd_pr__pfet_g5v0d10v5 ad=4.8 pd=17.2 as=4.8 ps=17.2 w=8 l=8
X58 a_5880_10660.t0 vrefb.t2 w_12740_11630.t1 vdd.t36 sky130_fd_pr__pfet_g5v0d10v5 ad=17.6 pd=34.2 as=8.8 ps=17.1 w=16 l=2
X59 a_1400_10660.t2 vrefb.t4 w_9880_11630.t3 vdd.t34 sky130_fd_pr__pfet_g5v0d10v5 ad=17.6 pd=34.2 as=8.8 ps=17.1 w=16 l=2
X60 w_12740_11630.t0 vrefb.t3 a_5880_10660.t3 vdd.t35 sky130_fd_pr__pfet_g5v0d10v5 ad=8.8 pd=17.1 as=8.8 ps=17.1 w=16 l=2
R0 a_13460_550.t3 a_13460_550.n1 49.4143
R1 a_13460_550.n1 a_13460_550.n2 0.96925
R2 a_13460_550.n2 a_13460_550.t4 229.931
R3 a_13460_550.n1 a_13460_550.t2 229.931
R4 a_13460_550.n2 a_13460_550.n0 27.7181
R5 a_13460_550.n0 a_13460_550.t0 6.56613
R6 a_13460_550.n0 a_13460_550.t1 6.56613
R7 a_14480_2450.n0 a_14480_2450.t4 6.56613
R8 a_14480_2450.t0 a_14480_2450.n0 6.56613
R9 a_14480_2450.n0 a_14480_2450.n2 28.1383
R10 a_14480_2450.n2 a_14480_2450.t3 34.7044
R11 a_14480_2450.n2 a_14480_2450.n1 26.2013
R12 a_14480_2450.n1 a_14480_2450.t2 6.56613
R13 a_14480_2450.n1 a_14480_2450.t1 6.56613
R14 a_1840_1350.t0 a_1840_1350.n3 49.305
R15 a_1840_1350.n3 a_1840_1350.n1 3.74112
R16 a_1840_1350.n1 a_1840_1350.n2 0.9005
R17 a_1840_1350.n2 a_1840_1350.t4 391.228
R18 a_1840_1350.n2 a_1840_1350.t5 390.572
R19 a_1840_1350.n3 a_1840_1350.t1 5.8938
R20 a_1840_1350.n1 a_1840_1350.n0 26.2337
R21 a_1840_1350.n0 a_1840_1350.t2 6.56613
R22 a_1840_1350.n0 a_1840_1350.t3 6.56613
R23 a_600_1350.t3 a_600_1350.n1 49.3518
R24 a_600_1350.n1 a_600_1350.n2 0.96925
R25 a_600_1350.n2 a_600_1350.t4 229.869
R26 a_600_1350.n1 a_600_1350.t2 229.869
R27 a_600_1350.n2 a_600_1350.n0 28.9587
R28 a_600_1350.n0 a_600_1350.t1 6.56613
R29 a_600_1350.n0 a_600_1350.t0 6.56613
R30 a_2374_3250.n0 a_2374_3250.t0 6.56613
R31 a_2374_3250.t3 a_2374_3250.n0 6.56613
R32 a_2374_3250.n0 a_2374_3250.n2 26.2008
R33 a_2374_3250.n2 a_2374_3250.t4 34.7044
R34 a_2374_3250.n2 a_2374_3250.n1 28.1387
R35 a_2374_3250.n1 a_2374_3250.t2 6.56613
R36 a_2374_3250.n1 a_2374_3250.t1 6.56613
R37 ve.t0 ve.n0 7345.2
R38 ve.n4 ve.n2 39.9267
R39 ve.n4 ve.n3 37.8211
R40 ve.n1 ve.t0 34.7998
R41 ve.n1 ve.t1 33.4556
R42 ve.n2 ve.t3 15.6755
R43 ve.n2 ve.t4 15.6755
R44 ve.n3 ve.t5 15.6755
R45 ve.n3 ve.t2 15.6755
R46 ve ve.n5 3.4105
R47 ve.n5 ve.n1 2.06004
R48 ve.n5 ve.n4 0.1932
R49 a_4860_8760.t3 a_4860_8760.n1 49.4143
R50 a_4860_8760.n1 a_4860_8760.n2 0.96925
R51 a_4860_8760.n2 a_4860_8760.t4 229.931
R52 a_4860_8760.n1 a_4860_8760.t2 229.931
R53 a_4860_8760.n2 a_4860_8760.n0 27.7181
R54 a_4860_8760.n0 a_4860_8760.t0 6.56613
R55 a_4860_8760.n0 a_4860_8760.t1 6.56613
R56 a_5880_10660.t0 a_5880_10660.n2 34.7043
R57 a_5880_10660.n2 a_5880_10660.n1 26.2013
R58 a_5880_10660.n1 a_5880_10660.t2 6.56613
R59 a_5880_10660.n1 a_5880_10660.t3 6.56613
R60 a_5880_10660.n2 a_5880_10660.n0 28.1387
R61 a_5880_10660.n0 a_5880_10660.t4 6.56613
R62 a_5880_10660.n0 a_5880_10660.t1 6.56613
R63 a_380_8760.t3 a_380_8760.n1 49.4143
R64 a_380_8760.n1 a_380_8760.n2 0.96925
R65 a_380_8760.n2 a_380_8760.t4 229.931
R66 a_380_8760.n1 a_380_8760.t2 229.931
R67 a_380_8760.n2 a_380_8760.n0 27.7181
R68 a_380_8760.n0 a_380_8760.t0 6.56613
R69 a_380_8760.n0 a_380_8760.t1 6.56613
R70 a_1400_10660.n0 a_1400_10660.t4 6.56613
R71 a_1400_10660.t0 a_1400_10660.n0 6.56613
R72 a_1400_10660.n0 a_1400_10660.n2 28.1383
R73 a_1400_10660.n2 a_1400_10660.t2 34.7044
R74 a_1400_10660.n2 a_1400_10660.n1 26.2013
R75 a_1400_10660.n1 a_1400_10660.t3 6.56613
R76 a_1400_10660.n1 a_1400_10660.t1 6.56613
R77 a_16741_18364.t0 a_16741_18364.t1 39.0211
R78 a_16237_18364.t0 a_16237_18364.t1 39.0211
R79 a_15733_18364.t0 a_15733_18364.t1 39.0211
R80 a_14725_18364.t0 a_14725_18364.t1 39.0211
R81 a_14221_18364.t0 a_14221_18364.t1 39.0211
R82 nu.n0 nu.t2 375.375
R83 nu.n0 nu.t3 374.406
R84 nu nu.t0 37.5877
R85 nu.n1 nu.n0 16.0419
R86 nu.n1 nu.t1 11.0979
R87 nu nu.n1 6.8205
R88 a_13100_15680.t3 a_13100_15680.n2 51.9925
R89 a_13100_15680.n2 a_13100_15680.n1 18.7819
R90 a_13100_15680.n1 a_13100_15680.t4 429.327
R91 a_13100_15680.n1 a_13100_15680.t1 4.78718
R92 a_13100_15680.n2 a_13100_15680.n0 26.1087
R93 a_13100_15680.n0 a_13100_15680.t0 6.56613
R94 a_13100_15680.n0 a_13100_15680.t2 6.56613
R95 a_13717_18364.t0 a_13717_18364.t1 39.0211
R96 vrefb.n0 vrefb.t2 375.594
R97 vrefb.n3 vrefb.t4 375.594
R98 vrefb.n0 vrefb.t3 374.625
R99 vrefb.n3 vrefb.t5 374.625
R100 vrefb.n2 vrefb.n1 26.7248
R101 vrefb.n1 vrefb.t0 22.7283
R102 vrefb.n1 vrefb.t1 21.9408
R103 vrefb.n4 vrefb.n3 4.8158
R104 vrefb.n2 vrefb.n0 3.622
R105 vrefb vrefb.n4 3.4105
R106 vrefb.n4 vrefb.n2 0.9123
R107 out.n0 out.t0 54.0028
R108 out.n1 out.n0 1.76925
R109 out out.n1 7.03787
R110 out.n1 out.t2 40.0248
R111 out.n0 out.t1 9.56115
R112 nsv.n1 nsv.t3 375.375
R113 nsv.n1 nsv.t4 374.406
R114 nsv nsv.t1 43.7096
R115 nsv.n0 nsv.t0 42.0272
R116 nsv.n0 nsv.t2 25.9627
R117 nsv nsv.n1 22.5529
R118 nsv nsv.n0 5.24112
R119 ndl.t0 ndl.n0 63.5128
R120 ndl ndl.n0 0.34425
R121 ndl.n0 ndl.t3 603.742
R122 ndl ndl.t1 602.524
R123 ndl ndl.t2 11.786
R124 w_12740_8770.n83 w_12740_8770.n82 585
R125 w_12740_8770.n85 w_12740_8770.n26 585
R126 w_12740_8770.n88 w_12740_8770.n87 585
R127 w_12740_8770.n24 w_12740_8770.n23 585
R128 w_12740_8770.n95 w_12740_8770.n94 585
R129 w_12740_8770.n97 w_12740_8770.n22 585
R130 w_12740_8770.n100 w_12740_8770.n99 585
R131 w_12740_8770.n58 w_12740_8770.n57 585
R132 w_12740_8770.n42 w_12740_8770.n39 585
R133 w_12740_8770.n64 w_12740_8770.n63 585
R134 w_12740_8770.n65 w_12740_8770.n35 585
R135 w_12740_8770.n68 w_12740_8770.n67 585
R136 w_12740_8770.n36 w_12740_8770.n33 585
R137 w_12740_8770.n73 w_12740_8770.n72 585
R138 w_12740_8770.n75 w_12740_8770.n74 585
R139 w_12740_8770.n28 w_12740_8770.n27 585
R140 w_12740_8770.n132 w_12740_8770.n131 585
R141 w_12740_8770.n135 w_12740_8770.n134 585
R142 w_12740_8770.n8 w_12740_8770.n6 585
R143 w_12740_8770.n46 w_12740_8770.n4 585
R144 w_12740_8770.n48 w_12740_8770.n47 585
R145 w_12740_8770.n50 w_12740_8770.n43 585
R146 w_12740_8770.n55 w_12740_8770.n54 585
R147 w_12740_8770.n10 w_12740_8770.n9 585
R148 w_12740_8770.n125 w_12740_8770.n124 585
R149 w_12740_8770.n122 w_12740_8770.n13 585
R150 w_12740_8770.n120 w_12740_8770.n119 585
R151 w_12740_8770.n15 w_12740_8770.n14 585
R152 w_12740_8770.n113 w_12740_8770.n112 585
R153 w_12740_8770.n110 w_12740_8770.n17 585
R154 w_12740_8770.n108 w_12740_8770.n107 585
R155 w_12740_8770.n19 w_12740_8770.n18 585
R156 w_12740_8770.n98 w_12740_8770.t6 262.336
R157 w_12740_8770.n56 w_12740_8770.t6 262.336
R158 w_12740_8770.n84 w_12740_8770.t6 256.663
R159 w_12740_8770.n86 w_12740_8770.t6 256.663
R160 w_12740_8770.n96 w_12740_8770.t6 256.663
R161 w_12740_8770.n37 w_12740_8770.t6 256.663
R162 w_12740_8770.n66 w_12740_8770.t6 256.663
R163 w_12740_8770.n32 w_12740_8770.t6 256.663
R164 w_12740_8770.n133 w_12740_8770.t6 256.663
R165 w_12740_8770.n45 w_12740_8770.t6 256.663
R166 w_12740_8770.n44 w_12740_8770.t6 256.663
R167 w_12740_8770.n121 w_12740_8770.t6 256.663
R168 w_12740_8770.n111 w_12740_8770.t6 256.663
R169 w_12740_8770.n109 w_12740_8770.t6 256.663
R170 w_12740_8770.n31 w_12740_8770.t6 243.918
R171 w_12740_8770.n123 w_12740_8770.t6 243.918
R172 w_12740_8770.n57 w_12740_8770.n42 233.037
R173 w_12740_8770.n108 w_12740_8770.n18 233.037
R174 w_12740_8770.n87 w_12740_8770.n85 163.367
R175 w_12740_8770.n95 w_12740_8770.n23 163.367
R176 w_12740_8770.n99 w_12740_8770.n97 163.367
R177 w_12740_8770.n74 w_12740_8770.n73 163.367
R178 w_12740_8770.n67 w_12740_8770.n36 163.367
R179 w_12740_8770.n65 w_12740_8770.n64 163.367
R180 w_12740_8770.n55 w_12740_8770.n43 163.367
R181 w_12740_8770.n47 w_12740_8770.n46 163.367
R182 w_12740_8770.n134 w_12740_8770.n8 163.367
R183 w_12740_8770.n112 w_12740_8770.n110 163.367
R184 w_12740_8770.n120 w_12740_8770.n14 163.367
R185 w_12740_8770.n124 w_12740_8770.n122 163.367
R186 w_12740_8770.n83 w_12740_8770.n27 134.537
R187 w_12740_8770.n132 w_12740_8770.n9 134.537
R188 w_12740_8770.n74 w_12740_8770.n31 97.1663
R189 w_12740_8770.n31 w_12740_8770.n27 97.1663
R190 w_12740_8770.n124 w_12740_8770.n123 97.1663
R191 w_12740_8770.n123 w_12740_8770.n9 97.1663
R192 w_12740_8770.n85 w_12740_8770.n84 71.676
R193 w_12740_8770.n87 w_12740_8770.n86 71.676
R194 w_12740_8770.n96 w_12740_8770.n95 71.676
R195 w_12740_8770.n84 w_12740_8770.n83 71.676
R196 w_12740_8770.n86 w_12740_8770.n23 71.676
R197 w_12740_8770.n97 w_12740_8770.n96 71.676
R198 w_12740_8770.n73 w_12740_8770.n32 71.676
R199 w_12740_8770.n67 w_12740_8770.n66 71.676
R200 w_12740_8770.n64 w_12740_8770.n37 71.676
R201 w_12740_8770.n42 w_12740_8770.n37 71.676
R202 w_12740_8770.n66 w_12740_8770.n65 71.676
R203 w_12740_8770.n36 w_12740_8770.n32 71.676
R204 w_12740_8770.n47 w_12740_8770.n44 71.676
R205 w_12740_8770.n45 w_12740_8770.n8 71.676
R206 w_12740_8770.n133 w_12740_8770.n132 71.676
R207 w_12740_8770.n134 w_12740_8770.n133 71.676
R208 w_12740_8770.n46 w_12740_8770.n45 71.676
R209 w_12740_8770.n44 w_12740_8770.n43 71.676
R210 w_12740_8770.n109 w_12740_8770.n108 71.676
R211 w_12740_8770.n112 w_12740_8770.n111 71.676
R212 w_12740_8770.n121 w_12740_8770.n120 71.676
R213 w_12740_8770.n122 w_12740_8770.n121 71.676
R214 w_12740_8770.n111 w_12740_8770.n14 71.676
R215 w_12740_8770.n110 w_12740_8770.n109 71.676
R216 w_12740_8770.n99 w_12740_8770.n98 60.3319
R217 w_12740_8770.n57 w_12740_8770.n56 60.3319
R218 w_12740_8770.n56 w_12740_8770.n55 60.3319
R219 w_12740_8770.n98 w_12740_8770.n18 60.3319
R220 w_12740_8770.t4 w_12740_8770.n140 37.7406
R221 w_12740_8770.n2 w_12740_8770.t2 32.1119
R222 w_12740_8770.n1 w_12740_8770.t0 27.7789
R223 w_12740_8770.n0 w_12740_8770.t1 27.7789
R224 w_12740_8770.n0 w_12740_8770.t5 18.5757
R225 w_12740_8770.n76 w_12740_8770.n28 16.4853
R226 w_12740_8770.n59 w_12740_8770.n58 16.4853
R227 w_12740_8770.n105 w_12740_8770.n19 16.4853
R228 w_12740_8770.n126 w_12740_8770.n10 16.4853
R229 w_12740_8770.n139 w_12740_8770.n2 15.9719
R230 w_12740_8770.n139 w_12740_8770.n138 13.719
R231 w_12740_8770.n48 w_12740_8770.n4 13.1884
R232 w_12740_8770.n6 w_12740_8770.n4 13.1884
R233 w_12740_8770.n88 w_12740_8770.n24 13.1884
R234 w_12740_8770.n94 w_12740_8770.n24 13.1884
R235 w_12740_8770.n68 w_12740_8770.n33 13.1884
R236 w_12740_8770.n68 w_12740_8770.n35 13.1884
R237 w_12740_8770.n113 w_12740_8770.n15 13.1884
R238 w_12740_8770.n119 w_12740_8770.n15 13.1884
R239 w_12740_8770.n50 w_12740_8770.n49 12.4126
R240 w_12740_8770.n136 w_12740_8770.n135 12.4126
R241 w_12740_8770.n89 w_12740_8770.n26 12.4126
R242 w_12740_8770.n93 w_12740_8770.n22 12.4126
R243 w_12740_8770.n72 w_12740_8770.n71 12.4126
R244 w_12740_8770.n63 w_12740_8770.n38 12.4126
R245 w_12740_8770.n114 w_12740_8770.n17 12.4126
R246 w_12740_8770.n118 w_12740_8770.n13 12.4126
R247 w_12740_8770.n54 w_12740_8770.n53 11.6369
R248 w_12740_8770.n131 w_12740_8770.n7 11.6369
R249 w_12740_8770.n82 w_12740_8770.n81 11.6369
R250 w_12740_8770.n100 w_12740_8770.n21 11.6369
R251 w_12740_8770.n75 w_12740_8770.n30 11.6369
R252 w_12740_8770.n62 w_12740_8770.n39 11.6369
R253 w_12740_8770.n107 w_12740_8770.n106 11.6369
R254 w_12740_8770.n125 w_12740_8770.n12 11.6369
R255 w_12740_8770.n58 w_12740_8770.n41 10.0853
R256 w_12740_8770.n130 w_12740_8770.n10 10.0853
R257 w_12740_8770.n80 w_12740_8770.n28 10.0853
R258 w_12740_8770.n101 w_12740_8770.n19 10.0853
R259 w_12740_8770.n140 w_12740_8770.n139 9.3325
R260 w_12740_8770.n51 w_12740_8770.n41 9.3005
R261 w_12740_8770.n53 w_12740_8770.n52 9.3005
R262 w_12740_8770.n49 w_12740_8770.n3 9.3005
R263 w_12740_8770.n80 w_12740_8770.n79 9.3005
R264 w_12740_8770.n81 w_12740_8770.n25 9.3005
R265 w_12740_8770.n90 w_12740_8770.n89 9.3005
R266 w_12740_8770.n91 w_12740_8770.n24 9.3005
R267 w_12740_8770.n93 w_12740_8770.n92 9.3005
R268 w_12740_8770.n21 w_12740_8770.n20 9.3005
R269 w_12740_8770.n102 w_12740_8770.n101 9.3005
R270 w_12740_8770.n78 w_12740_8770.n28 9.3005
R271 w_12740_8770.n77 w_12740_8770.n76 9.3005
R272 w_12740_8770.n30 w_12740_8770.n29 9.3005
R273 w_12740_8770.n71 w_12740_8770.n70 9.3005
R274 w_12740_8770.n69 w_12740_8770.n68 9.3005
R275 w_12740_8770.n38 w_12740_8770.n34 9.3005
R276 w_12740_8770.n62 w_12740_8770.n61 9.3005
R277 w_12740_8770.n60 w_12740_8770.n59 9.3005
R278 w_12740_8770.n58 w_12740_8770.n40 9.3005
R279 w_12740_8770.n105 w_12740_8770.n104 9.3005
R280 w_12740_8770.n106 w_12740_8770.n16 9.3005
R281 w_12740_8770.n115 w_12740_8770.n114 9.3005
R282 w_12740_8770.n116 w_12740_8770.n15 9.3005
R283 w_12740_8770.n118 w_12740_8770.n117 9.3005
R284 w_12740_8770.n12 w_12740_8770.n11 9.3005
R285 w_12740_8770.n127 w_12740_8770.n126 9.3005
R286 w_12740_8770.n128 w_12740_8770.n10 9.3005
R287 w_12740_8770.n103 w_12740_8770.n19 9.3005
R288 w_12740_8770.n130 w_12740_8770.n129 9.3005
R289 w_12740_8770.n7 w_12740_8770.n5 9.3005
R290 w_12740_8770.n137 w_12740_8770.n136 9.3005
R291 w_12740_8770.n138 w_12740_8770.n4 9.3005
R292 w_12740_8770.n2 w_12740_8770.n1 6.2505
R293 w_12740_8770.n54 w_12740_8770.n41 2.32777
R294 w_12740_8770.n131 w_12740_8770.n130 2.32777
R295 w_12740_8770.n82 w_12740_8770.n80 2.32777
R296 w_12740_8770.n101 w_12740_8770.n100 2.32777
R297 w_12740_8770.n76 w_12740_8770.n75 2.32777
R298 w_12740_8770.n59 w_12740_8770.n39 2.32777
R299 w_12740_8770.n107 w_12740_8770.n105 2.32777
R300 w_12740_8770.n126 w_12740_8770.n125 2.32777
R301 w_12740_8770.n140 w_12740_8770.t3 1.58836
R302 w_12740_8770.n53 w_12740_8770.n50 1.55202
R303 w_12740_8770.n135 w_12740_8770.n7 1.55202
R304 w_12740_8770.n81 w_12740_8770.n26 1.55202
R305 w_12740_8770.n22 w_12740_8770.n21 1.55202
R306 w_12740_8770.n72 w_12740_8770.n30 1.55202
R307 w_12740_8770.n63 w_12740_8770.n62 1.55202
R308 w_12740_8770.n106 w_12740_8770.n17 1.55202
R309 w_12740_8770.n13 w_12740_8770.n12 1.55202
R310 w_12740_8770.n1 w_12740_8770.n0 1.313
R311 w_12740_8770.n49 w_12740_8770.n48 0.776258
R312 w_12740_8770.n136 w_12740_8770.n6 0.776258
R313 w_12740_8770.n89 w_12740_8770.n88 0.776258
R314 w_12740_8770.n94 w_12740_8770.n93 0.776258
R315 w_12740_8770.n71 w_12740_8770.n33 0.776258
R316 w_12740_8770.n38 w_12740_8770.n35 0.776258
R317 w_12740_8770.n114 w_12740_8770.n113 0.776258
R318 w_12740_8770.n119 w_12740_8770.n118 0.776258
R319 w_12740_8770.n78 w_12740_8770.n77 0.18369
R320 w_12740_8770.n60 w_12740_8770.n40 0.18369
R321 w_12740_8770.n104 w_12740_8770.n103 0.18369
R322 w_12740_8770.n128 w_12740_8770.n127 0.18369
R323 w_12740_8770.n52 w_12740_8770.n51 0.155672
R324 w_12740_8770.n52 w_12740_8770.n3 0.155672
R325 w_12740_8770.n79 w_12740_8770.n25 0.155672
R326 w_12740_8770.n90 w_12740_8770.n25 0.155672
R327 w_12740_8770.n91 w_12740_8770.n90 0.155672
R328 w_12740_8770.n92 w_12740_8770.n91 0.155672
R329 w_12740_8770.n92 w_12740_8770.n20 0.155672
R330 w_12740_8770.n102 w_12740_8770.n20 0.155672
R331 w_12740_8770.n77 w_12740_8770.n29 0.155672
R332 w_12740_8770.n70 w_12740_8770.n29 0.155672
R333 w_12740_8770.n70 w_12740_8770.n69 0.155672
R334 w_12740_8770.n69 w_12740_8770.n34 0.155672
R335 w_12740_8770.n61 w_12740_8770.n34 0.155672
R336 w_12740_8770.n61 w_12740_8770.n60 0.155672
R337 w_12740_8770.n104 w_12740_8770.n16 0.155672
R338 w_12740_8770.n115 w_12740_8770.n16 0.155672
R339 w_12740_8770.n116 w_12740_8770.n115 0.155672
R340 w_12740_8770.n117 w_12740_8770.n116 0.155672
R341 w_12740_8770.n117 w_12740_8770.n11 0.155672
R342 w_12740_8770.n127 w_12740_8770.n11 0.155672
R343 w_12740_8770.n137 w_12740_8770.n5 0.155672
R344 w_12740_8770.n129 w_12740_8770.n5 0.155672
R345 w_12740_8770.n138 w_12740_8770.n3 0.136276
R346 w_12740_8770.n138 w_12740_8770.n137 0.136276
R347 w_12740_8770.n51 w_12740_8770.n40 0.12119
R348 w_12740_8770.n79 w_12740_8770.n78 0.12119
R349 w_12740_8770.n103 w_12740_8770.n102 0.12119
R350 w_12740_8770.n129 w_12740_8770.n128 0.12119
R351 w_12740_11630.t2 w_12740_11630.n1 51.9925
R352 w_12740_11630.n1 w_12740_11630.n140 9.28925
R353 w_12740_11630.n140 w_12740_11630.n139 13.1391
R354 w_12740_11630.n139 w_12740_11630.t4 375.594
R355 w_12740_11630.n139 w_12740_11630.t5 374.625
R356 w_12740_11630.n140 w_12740_11630.n138 1.622
R357 w_12740_11630.n138 w_12740_11630.t3 12.8135
R358 w_12740_11630.n138 w_12740_11630.n2 14.3265
R359 w_12740_11630.n2 w_12740_11630.n3 9.3005
R360 w_12740_11630.n5 w_12740_11630.n4 9.3005
R361 w_12740_11630.n7 w_12740_11630.n6 9.3005
R362 w_12740_11630.n9 w_12740_11630.n8 9.3005
R363 w_12740_11630.n9 w_12740_11630.n10 0.12119
R364 w_12740_11630.n7 w_12740_11630.n9 0.155672
R365 w_12740_11630.n5 w_12740_11630.n7 0.155672
R366 w_12740_11630.n2 w_12740_11630.n5 0.136276
R367 w_12740_11630.n12 w_12740_11630.n11 9.3005
R368 w_12740_11630.n10 w_12740_11630.n13 9.3005
R369 w_12740_11630.n15 w_12740_11630.n14 9.3005
R370 w_12740_11630.n17 w_12740_11630.n16 9.3005
R371 w_12740_11630.n19 w_12740_11630.n18 9.3005
R372 w_12740_11630.n21 w_12740_11630.n20 9.3005
R373 w_12740_11630.n23 w_12740_11630.n22 9.3005
R374 w_12740_11630.n25 w_12740_11630.n24 9.3005
R375 w_12740_11630.n137 w_12740_11630.n136 9.3005
R376 w_12740_11630.n10 w_12740_11630.n15 0.18369
R377 w_12740_11630.n15 w_12740_11630.n17 0.155672
R378 w_12740_11630.n17 w_12740_11630.n19 0.155672
R379 w_12740_11630.n19 w_12740_11630.n21 0.155672
R380 w_12740_11630.n21 w_12740_11630.n23 0.155672
R381 w_12740_11630.n23 w_12740_11630.n25 0.155672
R382 w_12740_11630.n25 w_12740_11630.n137 0.155672
R383 w_12740_11630.n137 w_12740_11630.n12 0.18369
R384 w_12740_11630.n26 w_12740_11630.n115 60.3319
R385 w_12740_11630.n11 w_12740_11630.n26 585
R386 w_12740_11630.t6 w_12740_11630.n30 256.663
R387 w_12740_11630.n32 w_12740_11630.n31 585
R388 w_12740_11630.n33 w_12740_11630.n30 71.676
R389 w_12740_11630.n34 w_12740_11630.n33 585
R390 w_12740_11630.t6 w_12740_11630.n35 256.663
R391 w_12740_11630.n37 w_12740_11630.n36 585
R392 w_12740_11630.n38 w_12740_11630.n35 71.676
R393 w_12740_11630.n20 w_12740_11630.n38 585
R394 w_12740_11630.t6 w_12740_11630.n39 256.663
R395 w_12740_11630.n41 w_12740_11630.n40 585
R396 w_12740_11630.n39 w_12740_11630.n42 71.676
R397 w_12740_11630.n43 w_12740_11630.n42 585
R398 w_12740_11630.t6 w_12740_11630.n44 243.918
R399 w_12740_11630.n46 w_12740_11630.n45 585
R400 w_12740_11630.n135 w_12740_11630.n44 97.1663
R401 w_12740_11630.n13 w_12740_11630.n135 585
R402 w_12740_11630.n13 w_12740_11630.n14 16.4853
R403 w_12740_11630.n14 w_12740_11630.n46 2.32777
R404 w_12740_11630.n46 w_12740_11630.n16 11.6369
R405 w_12740_11630.n16 w_12740_11630.n43 1.55202
R406 w_12740_11630.n43 w_12740_11630.n18 12.4126
R407 w_12740_11630.n18 w_12740_11630.n41 0.776258
R408 w_12740_11630.n41 w_12740_11630.n20 13.1884
R409 w_12740_11630.n20 w_12740_11630.n37 13.1884
R410 w_12740_11630.n22 w_12740_11630.n37 0.776258
R411 w_12740_11630.n22 w_12740_11630.n34 12.4126
R412 w_12740_11630.n24 w_12740_11630.n34 1.55202
R413 w_12740_11630.n24 w_12740_11630.n32 11.6369
R414 w_12740_11630.n136 w_12740_11630.n32 2.32777
R415 w_12740_11630.n136 w_12740_11630.n11 16.4853
R416 w_12740_11630.n44 w_12740_11630.n45 97.1663
R417 w_12740_11630.n45 w_12740_11630.n42 163.367
R418 w_12740_11630.n40 w_12740_11630.n39 71.676
R419 w_12740_11630.n40 w_12740_11630.n38 163.367
R420 w_12740_11630.n35 w_12740_11630.n36 71.676
R421 w_12740_11630.n36 w_12740_11630.n33 163.367
R422 w_12740_11630.n30 w_12740_11630.n31 71.676
R423 w_12740_11630.n31 w_12740_11630.n26 233.037
R424 w_12740_11630.n63 w_12740_11630.t6 262.336
R425 w_12740_11630.n48 w_12740_11630.n47 585
R426 w_12740_11630.n51 w_12740_11630.n49 71.676
R427 w_12740_11630.n50 w_12740_11630.n49 585
R428 w_12740_11630.t6 w_12740_11630.n51 256.663
R429 w_12740_11630.n53 w_12740_11630.n52 585
R430 w_12740_11630.n54 w_12740_11630.n55 71.676
R431 w_12740_11630.n3 w_12740_11630.n54 585
R432 w_12740_11630.t6 w_12740_11630.n55 256.663
R433 w_12740_11630.n57 w_12740_11630.n56 585
R434 w_12740_11630.n58 w_12740_11630.n60 71.676
R435 w_12740_11630.n59 w_12740_11630.n58 585
R436 w_12740_11630.t6 w_12740_11630.n60 256.663
R437 w_12740_11630.n62 w_12740_11630.n61 585
R438 w_12740_11630.n135 w_12740_11630.n61 134.537
R439 w_12740_11630.n61 w_12740_11630.n60 71.676
R440 w_12740_11630.n58 w_12740_11630.n56 163.367
R441 w_12740_11630.n56 w_12740_11630.n55 71.676
R442 w_12740_11630.n54 w_12740_11630.n52 163.367
R443 w_12740_11630.n52 w_12740_11630.n51 71.676
R444 w_12740_11630.n49 w_12740_11630.n47 163.367
R445 w_12740_11630.n47 w_12740_11630.n63 60.3319
R446 w_12740_11630.n65 w_12740_11630.n67 97.1663
R447 w_12740_11630.n66 w_12740_11630.n65 585
R448 w_12740_11630.t6 w_12740_11630.n67 243.918
R449 w_12740_11630.n69 w_12740_11630.n68 585
R450 w_12740_11630.t6 w_12740_11630.n29 256.663
R451 w_12740_11630.n71 w_12740_11630.n70 585
R452 w_12740_11630.n72 w_12740_11630.n29 71.676
R453 w_12740_11630.n73 w_12740_11630.n72 585
R454 w_12740_11630.t6 w_12740_11630.n28 256.663
R455 w_12740_11630.n75 w_12740_11630.n74 585
R456 w_12740_11630.n28 w_12740_11630.n76 71.676
R457 w_12740_11630.n77 w_12740_11630.n76 585
R458 w_12740_11630.t6 w_12740_11630.n27 256.663
R459 w_12740_11630.n79 w_12740_11630.n78 585
R460 w_12740_11630.n27 w_12740_11630.n80 71.676
R461 w_12740_11630.n81 w_12740_11630.n80 585
R462 w_12740_11630.n64 w_12740_11630.n63 60.3319
R463 w_12740_11630.n82 w_12740_11630.n64 585
R464 w_12740_11630.n64 w_12740_11630.n80 233.037
R465 w_12740_11630.n78 w_12740_11630.n27 71.676
R466 w_12740_11630.n78 w_12740_11630.n76 163.367
R467 w_12740_11630.n74 w_12740_11630.n28 71.676
R468 w_12740_11630.n74 w_12740_11630.n72 163.367
R469 w_12740_11630.n29 w_12740_11630.n70 71.676
R470 w_12740_11630.n70 w_12740_11630.n68 163.367
R471 w_12740_11630.n68 w_12740_11630.n67 97.1663
R472 w_12740_11630.n89 w_12740_11630.n82 9.3005
R473 w_12740_11630.n91 w_12740_11630.n90 9.3005
R474 w_12740_11630.n93 w_12740_11630.n92 9.3005
R475 w_12740_11630.n95 w_12740_11630.n94 9.3005
R476 w_12740_11630.n96 w_12740_11630.n75 9.3005
R477 w_12740_11630.n98 w_12740_11630.n97 9.3005
R478 w_12740_11630.n100 w_12740_11630.n99 9.3005
R479 w_12740_11630.n102 w_12740_11630.n101 9.3005
R480 w_12740_11630.n134 w_12740_11630.n66 9.3005
R481 w_12740_11630.n82 w_12740_11630.n90 16.4853
R482 w_12740_11630.n90 w_12740_11630.n81 2.32777
R483 w_12740_11630.n81 w_12740_11630.n92 11.6369
R484 w_12740_11630.n92 w_12740_11630.n79 1.55202
R485 w_12740_11630.n79 w_12740_11630.n94 12.4126
R486 w_12740_11630.n94 w_12740_11630.n77 0.776258
R487 w_12740_11630.n77 w_12740_11630.n75 13.1884
R488 w_12740_11630.n75 w_12740_11630.n73 13.1884
R489 w_12740_11630.n97 w_12740_11630.n73 0.776258
R490 w_12740_11630.n97 w_12740_11630.n71 12.4126
R491 w_12740_11630.n99 w_12740_11630.n71 1.55202
R492 w_12740_11630.n99 w_12740_11630.n69 11.6369
R493 w_12740_11630.n101 w_12740_11630.n69 2.32777
R494 w_12740_11630.n101 w_12740_11630.n66 16.4853
R495 w_12740_11630.n89 w_12740_11630.n91 0.18369
R496 w_12740_11630.n91 w_12740_11630.n93 0.155672
R497 w_12740_11630.n93 w_12740_11630.n95 0.155672
R498 w_12740_11630.n95 w_12740_11630.n96 0.155672
R499 w_12740_11630.n96 w_12740_11630.n98 0.155672
R500 w_12740_11630.n98 w_12740_11630.n100 0.155672
R501 w_12740_11630.n100 w_12740_11630.n102 0.155672
R502 w_12740_11630.n102 w_12740_11630.n134 0.18369
R503 w_12740_11630.n104 w_12740_11630.n103 9.3005
R504 w_12740_11630.n106 w_12740_11630.n105 9.3005
R505 w_12740_11630.n108 w_12740_11630.n107 9.3005
R506 w_12740_11630.n110 w_12740_11630.n109 9.3005
R507 w_12740_11630.n112 w_12740_11630.n111 9.3005
R508 w_12740_11630.n114 w_12740_11630.n113 9.3005
R509 w_12740_11630.n133 w_12740_11630.n132 9.3005
R510 w_12740_11630.n12 w_12740_11630.n104 0.12119
R511 w_12740_11630.n104 w_12740_11630.n106 0.155672
R512 w_12740_11630.n106 w_12740_11630.n108 0.155672
R513 w_12740_11630.n108 w_12740_11630.n110 0.155672
R514 w_12740_11630.n112 w_12740_11630.n110 0.155672
R515 w_12740_11630.n114 w_12740_11630.n112 0.155672
R516 w_12740_11630.n133 w_12740_11630.n114 0.155672
R517 w_12740_11630.n134 w_12740_11630.n133 0.12119
R518 w_12740_11630.t6 w_12740_11630.n115 262.336
R519 w_12740_11630.n117 w_12740_11630.n116 585
R520 w_12740_11630.n120 w_12740_11630.n118 71.676
R521 w_12740_11630.n119 w_12740_11630.n118 585
R522 w_12740_11630.t6 w_12740_11630.n120 256.663
R523 w_12740_11630.n122 w_12740_11630.n121 585
R524 w_12740_11630.n123 w_12740_11630.n124 71.676
R525 w_12740_11630.n109 w_12740_11630.n123 585
R526 w_12740_11630.t6 w_12740_11630.n124 256.663
R527 w_12740_11630.n126 w_12740_11630.n125 585
R528 w_12740_11630.t6 w_12740_11630.n127 256.663
R529 w_12740_11630.n129 w_12740_11630.n128 585
R530 w_12740_11630.n127 w_12740_11630.n130 71.676
R531 w_12740_11630.n131 w_12740_11630.n130 585
R532 w_12740_11630.n11 w_12740_11630.n103 10.0853
R533 w_12740_11630.n103 w_12740_11630.n117 2.32777
R534 w_12740_11630.n117 w_12740_11630.n105 11.6369
R535 w_12740_11630.n105 w_12740_11630.n119 1.55202
R536 w_12740_11630.n119 w_12740_11630.n107 12.4126
R537 w_12740_11630.n107 w_12740_11630.n122 0.776258
R538 w_12740_11630.n122 w_12740_11630.n109 13.1884
R539 w_12740_11630.n109 w_12740_11630.n126 13.1884
R540 w_12740_11630.n111 w_12740_11630.n126 0.776258
R541 w_12740_11630.n111 w_12740_11630.n129 12.4126
R542 w_12740_11630.n113 w_12740_11630.n129 1.55202
R543 w_12740_11630.n113 w_12740_11630.n131 11.6369
R544 w_12740_11630.n132 w_12740_11630.n131 2.32777
R545 w_12740_11630.n132 w_12740_11630.n66 10.0853
R546 w_12740_11630.n115 w_12740_11630.n116 60.3319
R547 w_12740_11630.n116 w_12740_11630.n118 163.367
R548 w_12740_11630.n121 w_12740_11630.n120 71.676
R549 w_12740_11630.n121 w_12740_11630.n123 163.367
R550 w_12740_11630.n124 w_12740_11630.n125 71.676
R551 w_12740_11630.n125 w_12740_11630.n128 163.367
R552 w_12740_11630.n128 w_12740_11630.n127 71.676
R553 w_12740_11630.n130 w_12740_11630.n65 134.537
R554 w_12740_11630.n84 w_12740_11630.n83 9.3005
R555 w_12740_11630.n86 w_12740_11630.n85 9.3005
R556 w_12740_11630.n88 w_12740_11630.n87 9.3005
R557 w_12740_11630.n2 w_12740_11630.n84 0.136276
R558 w_12740_11630.n84 w_12740_11630.n86 0.155672
R559 w_12740_11630.n86 w_12740_11630.n88 0.155672
R560 w_12740_11630.n88 w_12740_11630.n89 0.12119
R561 w_12740_11630.n13 w_12740_11630.n8 10.0853
R562 w_12740_11630.n8 w_12740_11630.n62 2.32777
R563 w_12740_11630.n62 w_12740_11630.n6 11.6369
R564 w_12740_11630.n6 w_12740_11630.n59 1.55202
R565 w_12740_11630.n59 w_12740_11630.n4 12.4126
R566 w_12740_11630.n4 w_12740_11630.n57 0.776258
R567 w_12740_11630.n57 w_12740_11630.n3 13.1884
R568 w_12740_11630.n3 w_12740_11630.n53 13.1884
R569 w_12740_11630.n83 w_12740_11630.n53 0.776258
R570 w_12740_11630.n83 w_12740_11630.n50 12.4126
R571 w_12740_11630.n85 w_12740_11630.n50 1.55202
R572 w_12740_11630.n85 w_12740_11630.n48 11.6369
R573 w_12740_11630.n87 w_12740_11630.n48 2.32777
R574 w_12740_11630.n87 w_12740_11630.n82 10.0853
R575 w_12740_11630.n1 w_12740_11630.n0 26.1087
R576 w_12740_11630.n0 w_12740_11630.t0 6.56613
R577 w_12740_11630.n0 w_12740_11630.t1 6.56613
R578 w_9880_11630.n82 w_9880_11630.n81 585
R579 w_9880_11630.n84 w_9880_11630.n25 585
R580 w_9880_11630.n87 w_9880_11630.n86 585
R581 w_9880_11630.n23 w_9880_11630.n22 585
R582 w_9880_11630.n94 w_9880_11630.n93 585
R583 w_9880_11630.n96 w_9880_11630.n21 585
R584 w_9880_11630.n99 w_9880_11630.n98 585
R585 w_9880_11630.n57 w_9880_11630.n56 585
R586 w_9880_11630.n41 w_9880_11630.n38 585
R587 w_9880_11630.n63 w_9880_11630.n62 585
R588 w_9880_11630.n64 w_9880_11630.n34 585
R589 w_9880_11630.n67 w_9880_11630.n66 585
R590 w_9880_11630.n35 w_9880_11630.n32 585
R591 w_9880_11630.n72 w_9880_11630.n71 585
R592 w_9880_11630.n74 w_9880_11630.n73 585
R593 w_9880_11630.n27 w_9880_11630.n26 585
R594 w_9880_11630.n131 w_9880_11630.n130 585
R595 w_9880_11630.n134 w_9880_11630.n133 585
R596 w_9880_11630.n7 w_9880_11630.n5 585
R597 w_9880_11630.n45 w_9880_11630.n3 585
R598 w_9880_11630.n47 w_9880_11630.n46 585
R599 w_9880_11630.n49 w_9880_11630.n42 585
R600 w_9880_11630.n54 w_9880_11630.n53 585
R601 w_9880_11630.n9 w_9880_11630.n8 585
R602 w_9880_11630.n124 w_9880_11630.n123 585
R603 w_9880_11630.n121 w_9880_11630.n12 585
R604 w_9880_11630.n119 w_9880_11630.n118 585
R605 w_9880_11630.n14 w_9880_11630.n13 585
R606 w_9880_11630.n112 w_9880_11630.n111 585
R607 w_9880_11630.n109 w_9880_11630.n16 585
R608 w_9880_11630.n107 w_9880_11630.n106 585
R609 w_9880_11630.n18 w_9880_11630.n17 585
R610 w_9880_11630.n97 w_9880_11630.t5 262.336
R611 w_9880_11630.n55 w_9880_11630.t5 262.336
R612 w_9880_11630.n83 w_9880_11630.t5 256.663
R613 w_9880_11630.n85 w_9880_11630.t5 256.663
R614 w_9880_11630.n95 w_9880_11630.t5 256.663
R615 w_9880_11630.n36 w_9880_11630.t5 256.663
R616 w_9880_11630.n65 w_9880_11630.t5 256.663
R617 w_9880_11630.n31 w_9880_11630.t5 256.663
R618 w_9880_11630.n132 w_9880_11630.t5 256.663
R619 w_9880_11630.n44 w_9880_11630.t5 256.663
R620 w_9880_11630.n43 w_9880_11630.t5 256.663
R621 w_9880_11630.n120 w_9880_11630.t5 256.663
R622 w_9880_11630.n110 w_9880_11630.t5 256.663
R623 w_9880_11630.n108 w_9880_11630.t5 256.663
R624 w_9880_11630.n30 w_9880_11630.t5 243.918
R625 w_9880_11630.n122 w_9880_11630.t5 243.918
R626 w_9880_11630.n56 w_9880_11630.n41 233.037
R627 w_9880_11630.n107 w_9880_11630.n17 233.037
R628 w_9880_11630.n86 w_9880_11630.n84 163.367
R629 w_9880_11630.n94 w_9880_11630.n22 163.367
R630 w_9880_11630.n98 w_9880_11630.n96 163.367
R631 w_9880_11630.n73 w_9880_11630.n72 163.367
R632 w_9880_11630.n66 w_9880_11630.n35 163.367
R633 w_9880_11630.n64 w_9880_11630.n63 163.367
R634 w_9880_11630.n54 w_9880_11630.n42 163.367
R635 w_9880_11630.n46 w_9880_11630.n45 163.367
R636 w_9880_11630.n133 w_9880_11630.n7 163.367
R637 w_9880_11630.n111 w_9880_11630.n109 163.367
R638 w_9880_11630.n119 w_9880_11630.n13 163.367
R639 w_9880_11630.n123 w_9880_11630.n121 163.367
R640 w_9880_11630.n82 w_9880_11630.n26 134.537
R641 w_9880_11630.n131 w_9880_11630.n8 134.537
R642 w_9880_11630.n73 w_9880_11630.n30 97.1663
R643 w_9880_11630.n30 w_9880_11630.n26 97.1663
R644 w_9880_11630.n123 w_9880_11630.n122 97.1663
R645 w_9880_11630.n122 w_9880_11630.n8 97.1663
R646 w_9880_11630.n84 w_9880_11630.n83 71.676
R647 w_9880_11630.n86 w_9880_11630.n85 71.676
R648 w_9880_11630.n95 w_9880_11630.n94 71.676
R649 w_9880_11630.n83 w_9880_11630.n82 71.676
R650 w_9880_11630.n85 w_9880_11630.n22 71.676
R651 w_9880_11630.n96 w_9880_11630.n95 71.676
R652 w_9880_11630.n72 w_9880_11630.n31 71.676
R653 w_9880_11630.n66 w_9880_11630.n65 71.676
R654 w_9880_11630.n63 w_9880_11630.n36 71.676
R655 w_9880_11630.n41 w_9880_11630.n36 71.676
R656 w_9880_11630.n65 w_9880_11630.n64 71.676
R657 w_9880_11630.n35 w_9880_11630.n31 71.676
R658 w_9880_11630.n46 w_9880_11630.n43 71.676
R659 w_9880_11630.n44 w_9880_11630.n7 71.676
R660 w_9880_11630.n132 w_9880_11630.n131 71.676
R661 w_9880_11630.n133 w_9880_11630.n132 71.676
R662 w_9880_11630.n45 w_9880_11630.n44 71.676
R663 w_9880_11630.n43 w_9880_11630.n42 71.676
R664 w_9880_11630.n108 w_9880_11630.n107 71.676
R665 w_9880_11630.n111 w_9880_11630.n110 71.676
R666 w_9880_11630.n120 w_9880_11630.n119 71.676
R667 w_9880_11630.n121 w_9880_11630.n120 71.676
R668 w_9880_11630.n110 w_9880_11630.n13 71.676
R669 w_9880_11630.n109 w_9880_11630.n108 71.676
R670 w_9880_11630.n98 w_9880_11630.n97 60.3319
R671 w_9880_11630.n56 w_9880_11630.n55 60.3319
R672 w_9880_11630.n55 w_9880_11630.n54 60.3319
R673 w_9880_11630.n97 w_9880_11630.n17 60.3319
R674 w_9880_11630.n1 w_9880_11630.t0 51.9928
R675 w_9880_11630.t1 w_9880_11630.n139 44.1472
R676 w_9880_11630.n1 w_9880_11630.n0 26.1087
R677 w_9880_11630.n75 w_9880_11630.n27 16.4853
R678 w_9880_11630.n58 w_9880_11630.n57 16.4853
R679 w_9880_11630.n104 w_9880_11630.n18 16.4853
R680 w_9880_11630.n125 w_9880_11630.n9 16.4853
R681 w_9880_11630.n47 w_9880_11630.n3 13.1884
R682 w_9880_11630.n5 w_9880_11630.n3 13.1884
R683 w_9880_11630.n87 w_9880_11630.n23 13.1884
R684 w_9880_11630.n93 w_9880_11630.n23 13.1884
R685 w_9880_11630.n67 w_9880_11630.n32 13.1884
R686 w_9880_11630.n67 w_9880_11630.n34 13.1884
R687 w_9880_11630.n112 w_9880_11630.n14 13.1884
R688 w_9880_11630.n118 w_9880_11630.n14 13.1884
R689 w_9880_11630.n138 w_9880_11630.n137 12.5748
R690 w_9880_11630.n49 w_9880_11630.n48 12.4126
R691 w_9880_11630.n135 w_9880_11630.n134 12.4126
R692 w_9880_11630.n88 w_9880_11630.n25 12.4126
R693 w_9880_11630.n92 w_9880_11630.n21 12.4126
R694 w_9880_11630.n71 w_9880_11630.n70 12.4126
R695 w_9880_11630.n62 w_9880_11630.n37 12.4126
R696 w_9880_11630.n113 w_9880_11630.n16 12.4126
R697 w_9880_11630.n117 w_9880_11630.n12 12.4126
R698 w_9880_11630.n53 w_9880_11630.n52 11.6369
R699 w_9880_11630.n130 w_9880_11630.n6 11.6369
R700 w_9880_11630.n81 w_9880_11630.n80 11.6369
R701 w_9880_11630.n99 w_9880_11630.n20 11.6369
R702 w_9880_11630.n74 w_9880_11630.n29 11.6369
R703 w_9880_11630.n61 w_9880_11630.n38 11.6369
R704 w_9880_11630.n106 w_9880_11630.n105 11.6369
R705 w_9880_11630.n124 w_9880_11630.n11 11.6369
R706 w_9880_11630.n138 w_9880_11630.n1 11.1907
R707 w_9880_11630.n57 w_9880_11630.n40 10.0853
R708 w_9880_11630.n129 w_9880_11630.n9 10.0853
R709 w_9880_11630.n79 w_9880_11630.n27 10.0853
R710 w_9880_11630.n100 w_9880_11630.n18 10.0853
R711 w_9880_11630.n50 w_9880_11630.n40 9.3005
R712 w_9880_11630.n52 w_9880_11630.n51 9.3005
R713 w_9880_11630.n48 w_9880_11630.n2 9.3005
R714 w_9880_11630.n79 w_9880_11630.n78 9.3005
R715 w_9880_11630.n80 w_9880_11630.n24 9.3005
R716 w_9880_11630.n89 w_9880_11630.n88 9.3005
R717 w_9880_11630.n90 w_9880_11630.n23 9.3005
R718 w_9880_11630.n92 w_9880_11630.n91 9.3005
R719 w_9880_11630.n20 w_9880_11630.n19 9.3005
R720 w_9880_11630.n101 w_9880_11630.n100 9.3005
R721 w_9880_11630.n77 w_9880_11630.n27 9.3005
R722 w_9880_11630.n76 w_9880_11630.n75 9.3005
R723 w_9880_11630.n29 w_9880_11630.n28 9.3005
R724 w_9880_11630.n70 w_9880_11630.n69 9.3005
R725 w_9880_11630.n68 w_9880_11630.n67 9.3005
R726 w_9880_11630.n37 w_9880_11630.n33 9.3005
R727 w_9880_11630.n61 w_9880_11630.n60 9.3005
R728 w_9880_11630.n59 w_9880_11630.n58 9.3005
R729 w_9880_11630.n57 w_9880_11630.n39 9.3005
R730 w_9880_11630.n104 w_9880_11630.n103 9.3005
R731 w_9880_11630.n105 w_9880_11630.n15 9.3005
R732 w_9880_11630.n114 w_9880_11630.n113 9.3005
R733 w_9880_11630.n115 w_9880_11630.n14 9.3005
R734 w_9880_11630.n117 w_9880_11630.n116 9.3005
R735 w_9880_11630.n11 w_9880_11630.n10 9.3005
R736 w_9880_11630.n126 w_9880_11630.n125 9.3005
R737 w_9880_11630.n127 w_9880_11630.n9 9.3005
R738 w_9880_11630.n102 w_9880_11630.n18 9.3005
R739 w_9880_11630.n129 w_9880_11630.n128 9.3005
R740 w_9880_11630.n6 w_9880_11630.n4 9.3005
R741 w_9880_11630.n136 w_9880_11630.n135 9.3005
R742 w_9880_11630.n137 w_9880_11630.n3 9.3005
R743 w_9880_11630.n139 w_9880_11630.t4 7.77271
R744 w_9880_11630.n0 w_9880_11630.t3 6.56613
R745 w_9880_11630.n0 w_9880_11630.t2 6.56613
R746 w_9880_11630.n139 w_9880_11630.n138 3.74875
R747 w_9880_11630.n53 w_9880_11630.n40 2.32777
R748 w_9880_11630.n130 w_9880_11630.n129 2.32777
R749 w_9880_11630.n81 w_9880_11630.n79 2.32777
R750 w_9880_11630.n100 w_9880_11630.n99 2.32777
R751 w_9880_11630.n75 w_9880_11630.n74 2.32777
R752 w_9880_11630.n58 w_9880_11630.n38 2.32777
R753 w_9880_11630.n106 w_9880_11630.n104 2.32777
R754 w_9880_11630.n125 w_9880_11630.n124 2.32777
R755 w_9880_11630.n52 w_9880_11630.n49 1.55202
R756 w_9880_11630.n134 w_9880_11630.n6 1.55202
R757 w_9880_11630.n80 w_9880_11630.n25 1.55202
R758 w_9880_11630.n21 w_9880_11630.n20 1.55202
R759 w_9880_11630.n71 w_9880_11630.n29 1.55202
R760 w_9880_11630.n62 w_9880_11630.n61 1.55202
R761 w_9880_11630.n105 w_9880_11630.n16 1.55202
R762 w_9880_11630.n12 w_9880_11630.n11 1.55202
R763 w_9880_11630.n48 w_9880_11630.n47 0.776258
R764 w_9880_11630.n135 w_9880_11630.n5 0.776258
R765 w_9880_11630.n88 w_9880_11630.n87 0.776258
R766 w_9880_11630.n93 w_9880_11630.n92 0.776258
R767 w_9880_11630.n70 w_9880_11630.n32 0.776258
R768 w_9880_11630.n37 w_9880_11630.n34 0.776258
R769 w_9880_11630.n113 w_9880_11630.n112 0.776258
R770 w_9880_11630.n118 w_9880_11630.n117 0.776258
R771 w_9880_11630.n77 w_9880_11630.n76 0.18369
R772 w_9880_11630.n59 w_9880_11630.n39 0.18369
R773 w_9880_11630.n103 w_9880_11630.n102 0.18369
R774 w_9880_11630.n127 w_9880_11630.n126 0.18369
R775 w_9880_11630.n51 w_9880_11630.n50 0.155672
R776 w_9880_11630.n51 w_9880_11630.n2 0.155672
R777 w_9880_11630.n78 w_9880_11630.n24 0.155672
R778 w_9880_11630.n89 w_9880_11630.n24 0.155672
R779 w_9880_11630.n90 w_9880_11630.n89 0.155672
R780 w_9880_11630.n91 w_9880_11630.n90 0.155672
R781 w_9880_11630.n91 w_9880_11630.n19 0.155672
R782 w_9880_11630.n101 w_9880_11630.n19 0.155672
R783 w_9880_11630.n76 w_9880_11630.n28 0.155672
R784 w_9880_11630.n69 w_9880_11630.n28 0.155672
R785 w_9880_11630.n69 w_9880_11630.n68 0.155672
R786 w_9880_11630.n68 w_9880_11630.n33 0.155672
R787 w_9880_11630.n60 w_9880_11630.n33 0.155672
R788 w_9880_11630.n60 w_9880_11630.n59 0.155672
R789 w_9880_11630.n103 w_9880_11630.n15 0.155672
R790 w_9880_11630.n114 w_9880_11630.n15 0.155672
R791 w_9880_11630.n115 w_9880_11630.n114 0.155672
R792 w_9880_11630.n116 w_9880_11630.n115 0.155672
R793 w_9880_11630.n116 w_9880_11630.n10 0.155672
R794 w_9880_11630.n126 w_9880_11630.n10 0.155672
R795 w_9880_11630.n136 w_9880_11630.n4 0.155672
R796 w_9880_11630.n128 w_9880_11630.n4 0.155672
R797 w_9880_11630.n137 w_9880_11630.n2 0.136276
R798 w_9880_11630.n137 w_9880_11630.n136 0.136276
R799 w_9880_11630.n50 w_9880_11630.n39 0.12119
R800 w_9880_11630.n78 w_9880_11630.n77 0.12119
R801 w_9880_11630.n102 w_9880_11630.n101 0.12119
R802 w_9880_11630.n128 w_9880_11630.n127 0.12119
R803 vdd.n7 vdd.n5 288.24
R804 vdd.n6 vdd.n1 8.52365
R805 vdd.n7 vdd.n6 288.24
R806 vdd.n7 vdd.n3 585
R807 vdd.n8 vdd.n4 8.52365
R808 vdd.n8 vdd.n7 288.24
R809 vdd.t17 vdd.n7 15.9968
R810 vdd.n5 vdd.n9 17.8237
R811 vdd.n10 vdd.n8 17.8237
R812 vdd.n11 vdd.n4 9.3005
R813 vdd.n12 vdd.n3 9.3005
R814 vdd.n13 vdd.n2 9.3005
R815 vdd.n14 vdd.n1 9.3005
R816 vdd.n1738 vdd.n0 9.3005
R817 vdd.n0 vdd.n5 8.52365
R818 vdd.n0 vdd.n1 17.2978
R819 vdd.n2 vdd.n6 8.52365
R820 vdd.n2 vdd.n3 17.2978
R821 vdd.n3 vdd.n4 17.2978
R822 vdd.n1738 vdd.n9 0.154821
R823 vdd.n14 vdd.n1738 0.154821
R824 vdd.n13 vdd.n14 0.154821
R825 vdd.n12 vdd.n13 0.154821
R826 vdd.n11 vdd.n12 0.154821
R827 vdd.n10 vdd.n11 0.154821
R828 vdd.n9 vdd.n15 0.982946
R829 vdd.n17 vdd.n16 9.3005
R830 vdd.n18 vdd.n19 3.56667
R831 vdd.n21 vdd.n20 9.3005
R832 vdd.n23 vdd.n22 9.3005
R833 vdd.n25 vdd.n24 9.3005
R834 vdd.n27 vdd.n26 9.3005
R835 vdd.n29 vdd.n28 9.3005
R836 vdd.n31 vdd.n30 9.3005
R837 vdd.n33 vdd.n32 9.3005
R838 vdd.n35 vdd.n34 9.3005
R839 vdd.n37 vdd.n36 9.3005
R840 vdd.n39 vdd.n38 9.3005
R841 vdd.n41 vdd.n40 9.3005
R842 vdd.n43 vdd.n42 9.3005
R843 vdd.n1737 vdd.n44 9.3005
R844 vdd.n21 vdd.n18 2.99921
R845 vdd.n23 vdd.n21 0.114136
R846 vdd.n25 vdd.n23 0.114136
R847 vdd.n27 vdd.n25 0.114136
R848 vdd.n29 vdd.n27 0.114136
R849 vdd.n31 vdd.n29 0.114136
R850 vdd.n33 vdd.n31 0.114136
R851 vdd.n35 vdd.n33 0.114136
R852 vdd.n37 vdd.n35 0.114136
R853 vdd.n39 vdd.n37 0.114136
R854 vdd.n41 vdd.n39 0.114136
R855 vdd.n43 vdd.n41 0.114136
R856 vdd.n1737 vdd.n43 0.114136
R857 vdd.n17 vdd.n1737 0.114136
R858 vdd.n15 vdd.n17 0.134591
R859 vdd.n67 vdd.n66 68.9104
R860 vdd.n66 vdd.n45 47.1822
R861 vdd.n44 vdd.n45 185
R862 vdd.n67 vdd.n65 68.9104
R863 vdd.n42 vdd.n46 185
R864 vdd.n65 vdd.n47 47.1822
R865 vdd.n40 vdd.n47 185
R866 vdd.n67 vdd.n64 68.9104
R867 vdd.n38 vdd.n48 185
R868 vdd.n64 vdd.n49 47.1822
R869 vdd.n36 vdd.n49 185
R870 vdd.n67 vdd.n63 68.9104
R871 vdd.n34 vdd.n50 185
R872 vdd.n63 vdd.n51 47.1822
R873 vdd.n32 vdd.n51 185
R874 vdd.n67 vdd.n62 68.9104
R875 vdd.n30 vdd.n52 185
R876 vdd.n62 vdd.n53 47.1822
R877 vdd.n28 vdd.n53 185
R878 vdd.n67 vdd.n61 68.9104
R879 vdd.n26 vdd.n54 185
R880 vdd.n61 vdd.n55 47.1822
R881 vdd.n24 vdd.n55 185
R882 vdd.n67 vdd.n60 68.9104
R883 vdd.n22 vdd.n56 185
R884 vdd.n60 vdd.n57 47.1822
R885 vdd.n20 vdd.n57 185
R886 vdd.n59 vdd.n67 68.9104
R887 vdd.n19 vdd.n58 185
R888 vdd.n59 vdd.n18 235.792
R889 vdd.n19 vdd.n20 11.6369
R890 vdd.n20 vdd.n22 11.6369
R891 vdd.n22 vdd.n24 11.6369
R892 vdd.n24 vdd.n26 11.6369
R893 vdd.n26 vdd.n28 11.6369
R894 vdd.n28 vdd.n30 11.6369
R895 vdd.n30 vdd.n32 11.6369
R896 vdd.n32 vdd.n34 11.6369
R897 vdd.n34 vdd.n36 11.6369
R898 vdd.n36 vdd.n38 11.6369
R899 vdd.n38 vdd.n40 11.6369
R900 vdd.n40 vdd.n42 11.6369
R901 vdd.n42 vdd.n44 11.6369
R902 vdd.n44 vdd.n16 11.6369
R903 vdd.n58 vdd.n59 47.1822
R904 vdd.n58 vdd.n57 126.668
R905 vdd.n56 vdd.n60 47.1822
R906 vdd.n56 vdd.n55 126.668
R907 vdd.n54 vdd.n61 47.1822
R908 vdd.n54 vdd.n53 126.668
R909 vdd.n52 vdd.n62 47.1822
R910 vdd.n52 vdd.n51 126.668
R911 vdd.n50 vdd.n63 47.1822
R912 vdd.n50 vdd.n49 126.668
R913 vdd.n48 vdd.n64 47.1822
R914 vdd.n48 vdd.n47 126.668
R915 vdd.n46 vdd.n65 47.1822
R916 vdd.n46 vdd.n45 126.668
R917 vdd.n16 vdd.n66 232.183
R918 vdd.n69 vdd.n70 232.183
R919 vdd.n68 vdd.n70 68.9104
R920 vdd.n642 vdd.n71 185
R921 vdd.n72 vdd.n74 47.1822
R922 vdd.n73 vdd.n72 185
R923 vdd.n68 vdd.n74 68.9104
R924 vdd.n76 vdd.n75 185
R925 vdd.n77 vdd.n79 47.1822
R926 vdd.n78 vdd.n77 185
R927 vdd.n68 vdd.n79 68.9104
R928 vdd.n81 vdd.n80 185
R929 vdd.n82 vdd.n84 47.1822
R930 vdd.n83 vdd.n82 185
R931 vdd.n68 vdd.n84 68.9104
R932 vdd.n86 vdd.n85 185
R933 vdd.n87 vdd.n89 47.1822
R934 vdd.n88 vdd.n87 185
R935 vdd.n68 vdd.n89 68.9104
R936 vdd.n91 vdd.n90 185
R937 vdd.n92 vdd.n94 47.1822
R938 vdd.n93 vdd.n92 185
R939 vdd.n68 vdd.n94 68.9104
R940 vdd.n96 vdd.n95 185
R941 vdd.n97 vdd.n99 47.1822
R942 vdd.n98 vdd.n97 185
R943 vdd.n68 vdd.n99 68.9104
R944 vdd.n101 vdd.n100 185
R945 vdd.n102 vdd.n104 47.1822
R946 vdd.n103 vdd.n102 185
R947 vdd.n104 vdd.n68 68.9104
R948 vdd.n67 vdd.t25 284.591
R949 vdd.n67 vdd.n1736 116.704
R950 vdd.n1736 vdd.t16 286.639
R951 vdd.n68 vdd.t16 284.591
R952 vdd.n186 vdd.n170 68.9104
R953 vdd.n571 vdd.n105 185
R954 vdd.n171 vdd.n106 47.1822
R955 vdd.n107 vdd.n106 185
R956 vdd.n186 vdd.n171 68.9104
R957 vdd.n109 vdd.n108 185
R958 vdd.n172 vdd.n110 47.1822
R959 vdd.n111 vdd.n110 185
R960 vdd.n186 vdd.n172 68.9104
R961 vdd.n113 vdd.n112 185
R962 vdd.n173 vdd.n114 47.1822
R963 vdd.n115 vdd.n114 185
R964 vdd.n186 vdd.n173 68.9104
R965 vdd.n117 vdd.n116 185
R966 vdd.n174 vdd.n118 47.1822
R967 vdd.n119 vdd.n118 185
R968 vdd.n186 vdd.n174 68.9104
R969 vdd.n121 vdd.n120 185
R970 vdd.n175 vdd.n122 47.1822
R971 vdd.n123 vdd.n122 185
R972 vdd.n186 vdd.n175 68.9104
R973 vdd.n125 vdd.n124 185
R974 vdd.n176 vdd.n126 47.1822
R975 vdd.n127 vdd.n126 185
R976 vdd.n186 vdd.n176 68.9104
R977 vdd.n129 vdd.n128 185
R978 vdd.n177 vdd.n130 47.1822
R979 vdd.n131 vdd.n130 185
R980 vdd.n186 vdd.n177 68.9104
R981 vdd.n133 vdd.n132 185
R982 vdd.n178 vdd.n134 47.1822
R983 vdd.n135 vdd.n134 185
R984 vdd.n186 vdd.n178 68.9104
R985 vdd.n137 vdd.n136 185
R986 vdd.n179 vdd.n138 47.1822
R987 vdd.n139 vdd.n138 185
R988 vdd.n186 vdd.n179 68.9104
R989 vdd.n141 vdd.n140 185
R990 vdd.n180 vdd.n142 47.1822
R991 vdd.n143 vdd.n142 185
R992 vdd.n186 vdd.n180 68.9104
R993 vdd.n145 vdd.n144 185
R994 vdd.n181 vdd.n146 47.1822
R995 vdd.n147 vdd.n146 185
R996 vdd.n186 vdd.n181 68.9104
R997 vdd.n149 vdd.n148 185
R998 vdd.n182 vdd.n150 47.1822
R999 vdd.n151 vdd.n150 185
R1000 vdd.n186 vdd.n182 68.9104
R1001 vdd.n153 vdd.n152 185
R1002 vdd.n183 vdd.n154 47.1822
R1003 vdd.n155 vdd.n154 185
R1004 vdd.n186 vdd.n183 68.9104
R1005 vdd.n157 vdd.n156 185
R1006 vdd.n184 vdd.n158 47.1822
R1007 vdd.n159 vdd.n158 185
R1008 vdd.n186 vdd.n184 68.9104
R1009 vdd.n161 vdd.n160 185
R1010 vdd.n185 vdd.n162 47.1822
R1011 vdd.n163 vdd.n162 185
R1012 vdd.n186 vdd.n185 68.9104
R1013 vdd.n165 vdd.n164 185
R1014 vdd.n186 vdd.n166 185
R1015 vdd.n167 vdd.n166 185
R1016 vdd.n187 vdd.n168 47.1822
R1017 vdd.n169 vdd.n168 185
R1018 vdd.n187 vdd.n186 68.9104
R1019 vdd.n572 vdd.n188 185
R1020 vdd.n190 vdd.n189 185
R1021 vdd.n191 vdd.n190 185
R1022 vdd.n193 vdd.n192 185
R1023 vdd.n194 vdd.n193 185
R1024 vdd.n196 vdd.n195 185
R1025 vdd.n197 vdd.n196 185
R1026 vdd.n199 vdd.n198 185
R1027 vdd.n200 vdd.n199 185
R1028 vdd.n202 vdd.n201 185
R1029 vdd.n203 vdd.n202 185
R1030 vdd.n205 vdd.n204 185
R1031 vdd.n206 vdd.n205 185
R1032 vdd.n208 vdd.n207 185
R1033 vdd.n209 vdd.n208 185
R1034 vdd.n211 vdd.n210 185
R1035 vdd.n212 vdd.n211 185
R1036 vdd.n214 vdd.n213 185
R1037 vdd.n215 vdd.n214 185
R1038 vdd.n217 vdd.n216 185
R1039 vdd.n218 vdd.n217 185
R1040 vdd.n220 vdd.n219 185
R1041 vdd.n221 vdd.n220 185
R1042 vdd.n223 vdd.n222 185
R1043 vdd.n224 vdd.n223 185
R1044 vdd.n225 vdd.n226 185
R1045 vdd.n227 vdd.n226 185
R1046 vdd.n228 vdd.n229 185
R1047 vdd.n230 vdd.n229 185
R1048 vdd.n233 vdd.n232 185
R1049 vdd.n315 vdd.n299 68.9104
R1050 vdd.n623 vdd.n234 185
R1051 vdd.n300 vdd.n235 47.1822
R1052 vdd.n236 vdd.n235 185
R1053 vdd.n315 vdd.n300 68.9104
R1054 vdd.n238 vdd.n237 185
R1055 vdd.n301 vdd.n239 47.1822
R1056 vdd.n240 vdd.n239 185
R1057 vdd.n315 vdd.n301 68.9104
R1058 vdd.n242 vdd.n241 185
R1059 vdd.n302 vdd.n243 47.1822
R1060 vdd.n244 vdd.n243 185
R1061 vdd.n315 vdd.n302 68.9104
R1062 vdd.n246 vdd.n245 185
R1063 vdd.n303 vdd.n247 47.1822
R1064 vdd.n248 vdd.n247 185
R1065 vdd.n315 vdd.n303 68.9104
R1066 vdd.n250 vdd.n249 185
R1067 vdd.n304 vdd.n251 47.1822
R1068 vdd.n252 vdd.n251 185
R1069 vdd.n315 vdd.n304 68.9104
R1070 vdd.n254 vdd.n253 185
R1071 vdd.n305 vdd.n255 47.1822
R1072 vdd.n256 vdd.n255 185
R1073 vdd.n315 vdd.n305 68.9104
R1074 vdd.n258 vdd.n257 185
R1075 vdd.n306 vdd.n259 47.1822
R1076 vdd.n260 vdd.n259 185
R1077 vdd.n315 vdd.n306 68.9104
R1078 vdd.n262 vdd.n261 185
R1079 vdd.n307 vdd.n263 47.1822
R1080 vdd.n264 vdd.n263 185
R1081 vdd.n315 vdd.n307 68.9104
R1082 vdd.n266 vdd.n265 185
R1083 vdd.n308 vdd.n267 47.1822
R1084 vdd.n268 vdd.n267 185
R1085 vdd.n315 vdd.n308 68.9104
R1086 vdd.n270 vdd.n269 185
R1087 vdd.n309 vdd.n271 47.1822
R1088 vdd.n272 vdd.n271 185
R1089 vdd.n315 vdd.n309 68.9104
R1090 vdd.n274 vdd.n273 185
R1091 vdd.n310 vdd.n275 47.1822
R1092 vdd.n276 vdd.n275 185
R1093 vdd.n315 vdd.n310 68.9104
R1094 vdd.n278 vdd.n277 185
R1095 vdd.n311 vdd.n279 47.1822
R1096 vdd.n280 vdd.n279 185
R1097 vdd.n315 vdd.n311 68.9104
R1098 vdd.n282 vdd.n281 185
R1099 vdd.n312 vdd.n283 47.1822
R1100 vdd.n284 vdd.n283 185
R1101 vdd.n315 vdd.n312 68.9104
R1102 vdd.n286 vdd.n285 185
R1103 vdd.n313 vdd.n287 47.1822
R1104 vdd.n288 vdd.n287 185
R1105 vdd.n315 vdd.n313 68.9104
R1106 vdd.n290 vdd.n289 185
R1107 vdd.n314 vdd.n291 47.1822
R1108 vdd.n292 vdd.n291 185
R1109 vdd.n315 vdd.n314 68.9104
R1110 vdd.n294 vdd.n293 185
R1111 vdd.n315 vdd.n295 185
R1112 vdd.n296 vdd.n295 185
R1113 vdd.n316 vdd.n297 47.1822
R1114 vdd.n298 vdd.n297 185
R1115 vdd.n316 vdd.n315 68.9104
R1116 vdd.n624 vdd.n317 185
R1117 vdd.n319 vdd.n318 185
R1118 vdd.n320 vdd.n319 185
R1119 vdd.n322 vdd.n321 185
R1120 vdd.n323 vdd.n322 185
R1121 vdd.n325 vdd.n324 185
R1122 vdd.n326 vdd.n325 185
R1123 vdd.n328 vdd.n327 185
R1124 vdd.n329 vdd.n328 185
R1125 vdd.n331 vdd.n330 185
R1126 vdd.n332 vdd.n331 185
R1127 vdd.n334 vdd.n333 185
R1128 vdd.n335 vdd.n334 185
R1129 vdd.n337 vdd.n336 185
R1130 vdd.n338 vdd.n337 185
R1131 vdd.n340 vdd.n339 185
R1132 vdd.n341 vdd.n340 185
R1133 vdd.n343 vdd.n342 185
R1134 vdd.n344 vdd.n343 185
R1135 vdd.n346 vdd.n345 185
R1136 vdd.n347 vdd.n346 185
R1137 vdd.n349 vdd.n348 185
R1138 vdd.n350 vdd.n349 185
R1139 vdd.n352 vdd.n351 185
R1140 vdd.n353 vdd.n352 185
R1141 vdd.n355 vdd.n354 185
R1142 vdd.n356 vdd.n355 185
R1143 vdd.n358 vdd.n357 185
R1144 vdd.n359 vdd.n358 185
R1145 vdd.n361 vdd.n360 185
R1146 vdd.n362 vdd.n361 185
R1147 vdd.n364 vdd.n363 185
R1148 vdd.n366 vdd.n365 185
R1149 vdd.n367 vdd.n366 185
R1150 vdd.n369 vdd.n368 185
R1151 vdd.n520 vdd.n369 185
R1152 vdd.n371 vdd.n370 185
R1153 vdd.n372 vdd.n371 185
R1154 vdd.n374 vdd.n373 185
R1155 vdd.n375 vdd.n374 185
R1156 vdd.n377 vdd.n376 185
R1157 vdd.n378 vdd.n377 185
R1158 vdd.n380 vdd.n379 185
R1159 vdd.n381 vdd.n380 185
R1160 vdd.n383 vdd.n382 185
R1161 vdd.n384 vdd.n383 185
R1162 vdd.n386 vdd.n385 185
R1163 vdd.n387 vdd.n386 185
R1164 vdd.n389 vdd.n388 185
R1165 vdd.n390 vdd.n389 185
R1166 vdd.n392 vdd.n391 185
R1167 vdd.n393 vdd.n392 185
R1168 vdd.n395 vdd.n394 185
R1169 vdd.n396 vdd.n395 185
R1170 vdd.n398 vdd.n397 185
R1171 vdd.n399 vdd.n398 185
R1172 vdd.n401 vdd.n400 185
R1173 vdd.n402 vdd.n401 185
R1174 vdd.n404 vdd.n403 185
R1175 vdd.n405 vdd.n404 185
R1176 vdd.n407 vdd.n406 185
R1177 vdd.n408 vdd.n407 185
R1178 vdd.n410 vdd.n409 185
R1179 vdd.n231 vdd.n228 99.7961
R1180 vdd.n228 vdd.n225 25.2665
R1181 vdd.n225 vdd.n222 25.2665
R1182 vdd.n222 vdd.n219 25.2665
R1183 vdd.n219 vdd.n216 25.2665
R1184 vdd.n216 vdd.n213 25.2665
R1185 vdd.n213 vdd.t10 12.6335
R1186 vdd.n210 vdd.t10 12.6335
R1187 vdd.n210 vdd.n207 25.2665
R1188 vdd.n207 vdd.n204 25.2665
R1189 vdd.n204 vdd.n201 25.2665
R1190 vdd.n201 vdd.n198 25.2665
R1191 vdd.n198 vdd.n195 25.2665
R1192 vdd.n195 vdd.n192 25.2665
R1193 vdd.n192 vdd.n189 25.2665
R1194 vdd.n189 vdd.n186 75.5457
R1195 vdd.n186 vdd.n363 172.061
R1196 vdd.n363 vdd.n360 25.2665
R1197 vdd.n360 vdd.n357 25.2665
R1198 vdd.n357 vdd.n354 25.2665
R1199 vdd.n354 vdd.n351 25.2665
R1200 vdd.n351 vdd.n348 25.2665
R1201 vdd.n348 vdd.n345 25.2665
R1202 vdd.n345 vdd.n342 25.2665
R1203 vdd.n342 vdd.t12 12.6335
R1204 vdd.n339 vdd.t12 12.6335
R1205 vdd.n339 vdd.n336 25.2665
R1206 vdd.n336 vdd.n333 25.2665
R1207 vdd.n333 vdd.n330 25.2665
R1208 vdd.n330 vdd.n327 25.2665
R1209 vdd.n327 vdd.n324 25.2665
R1210 vdd.n324 vdd.n321 25.2665
R1211 vdd.n321 vdd.n318 25.2665
R1212 vdd.n318 vdd.n315 75.5457
R1213 vdd.n315 vdd.n409 172.061
R1214 vdd.n409 vdd.n406 25.2665
R1215 vdd.n406 vdd.n403 25.2665
R1216 vdd.n403 vdd.n400 25.2665
R1217 vdd.n400 vdd.n397 25.2665
R1218 vdd.n397 vdd.n394 25.2665
R1219 vdd.n394 vdd.n391 25.2665
R1220 vdd.n391 vdd.n388 25.2665
R1221 vdd.n388 vdd.t14 12.6335
R1222 vdd.n385 vdd.t14 12.6335
R1223 vdd.n385 vdd.n382 25.2665
R1224 vdd.n382 vdd.n379 25.2665
R1225 vdd.n379 vdd.n376 25.2665
R1226 vdd.n376 vdd.n373 25.2665
R1227 vdd.n373 vdd.n370 25.2665
R1228 vdd.n370 vdd.n368 25.2665
R1229 vdd.n368 vdd.n365 25.2665
R1230 vdd.n365 vdd.n1736 63.1654
R1231 vdd.n412 vdd.n411 38.758
R1232 vdd.n413 vdd.n412 185
R1233 vdd.n415 vdd.n414 185
R1234 vdd.n416 vdd.n415 185
R1235 vdd.n418 vdd.n417 185
R1236 vdd.n419 vdd.n418 185
R1237 vdd.n421 vdd.n420 185
R1238 vdd.n422 vdd.n421 185
R1239 vdd.n424 vdd.n423 185
R1240 vdd.n425 vdd.n424 185
R1241 vdd.n427 vdd.n426 185
R1242 vdd.n428 vdd.n427 185
R1243 vdd.n430 vdd.n429 185
R1244 vdd.n431 vdd.n430 185
R1245 vdd.n433 vdd.n432 185
R1246 vdd.n434 vdd.n433 185
R1247 vdd.n436 vdd.n435 185
R1248 vdd.n437 vdd.n436 185
R1249 vdd.n439 vdd.n438 185
R1250 vdd.n440 vdd.n439 185
R1251 vdd.n442 vdd.n441 185
R1252 vdd.n443 vdd.n442 185
R1253 vdd.n445 vdd.n444 185
R1254 vdd.n446 vdd.n445 185
R1255 vdd.n448 vdd.n447 185
R1256 vdd.n449 vdd.n448 185
R1257 vdd.n452 vdd.n451 185
R1258 vdd.n450 vdd.n453 246.375
R1259 vdd.n411 vdd.n414 197.593
R1260 vdd.n414 vdd.n417 107.956
R1261 vdd.n417 vdd.n420 107.956
R1262 vdd.n420 vdd.n423 107.956
R1263 vdd.n423 vdd.n426 107.956
R1264 vdd.n426 vdd.n429 107.956
R1265 vdd.n429 vdd.t14 53.9778
R1266 vdd.t14 vdd.n432 53.9778
R1267 vdd.n432 vdd.n435 107.956
R1268 vdd.n435 vdd.n438 107.956
R1269 vdd.n438 vdd.n441 107.956
R1270 vdd.n441 vdd.n444 107.956
R1271 vdd.n444 vdd.n447 107.956
R1272 vdd.n447 vdd.n450 197.593
R1273 vdd.n454 vdd.n413 3.56667
R1274 vdd.n455 vdd.n416 9.3005
R1275 vdd.n456 vdd.n419 9.3005
R1276 vdd.n457 vdd.n422 9.3005
R1277 vdd.n458 vdd.n425 9.3005
R1278 vdd.n459 vdd.n428 9.3005
R1279 vdd.n460 vdd.n431 9.3005
R1280 vdd.n461 vdd.n434 9.3005
R1281 vdd.n462 vdd.n437 9.3005
R1282 vdd.n463 vdd.n440 9.3005
R1283 vdd.n464 vdd.n443 9.3005
R1284 vdd.n465 vdd.n446 9.3005
R1285 vdd.n466 vdd.n449 9.3005
R1286 vdd.n467 vdd.n452 9.3005
R1287 vdd.n1735 vdd.n453 9.3005
R1288 vdd.n413 vdd.n416 11.6369
R1289 vdd.n416 vdd.n419 11.6369
R1290 vdd.n419 vdd.n422 11.6369
R1291 vdd.n422 vdd.n425 11.6369
R1292 vdd.n425 vdd.n428 11.6369
R1293 vdd.n428 vdd.n431 11.6369
R1294 vdd.n431 vdd.n434 11.6369
R1295 vdd.n434 vdd.n437 11.6369
R1296 vdd.n437 vdd.n440 11.6369
R1297 vdd.n440 vdd.n443 11.6369
R1298 vdd.n443 vdd.n446 11.6369
R1299 vdd.n446 vdd.n449 11.6369
R1300 vdd.n449 vdd.n452 11.6369
R1301 vdd.n452 vdd.n453 11.6369
R1302 vdd.n455 vdd.n454 2.99921
R1303 vdd.n456 vdd.n455 0.114136
R1304 vdd.n457 vdd.n456 0.114136
R1305 vdd.n458 vdd.n457 0.114136
R1306 vdd.n459 vdd.n458 0.114136
R1307 vdd.n460 vdd.n459 0.114136
R1308 vdd.n461 vdd.n460 0.114136
R1309 vdd.n462 vdd.n461 0.114136
R1310 vdd.n463 vdd.n462 0.114136
R1311 vdd.n464 vdd.n463 0.114136
R1312 vdd.n465 vdd.n464 0.114136
R1313 vdd.n466 vdd.n465 0.114136
R1314 vdd.n467 vdd.n466 0.114136
R1315 vdd.n1735 vdd.n467 0.114136
R1316 vdd.n1734 vdd.n1735 0.132318
R1317 vdd.n1733 vdd.n1734 11.9261
R1318 vdd.n1733 vdd.n626 1.1661
R1319 vdd.n644 vdd.n1733 1.09184
R1320 vdd.n706 vdd.n644 1.4669
R1321 vdd vdd.n706 6.32231
R1322 vdd vdd.n1196 2.797
R1323 vdd.n1196 vdd.n1732 8.5382
R1324 vdd.n1732 vdd.n1488 9.31675
R1325 vdd.n1488 vdd.n1490 9.3005
R1326 vdd.n1492 vdd.n1491 9.3005
R1327 vdd.n1494 vdd.n1493 9.3005
R1328 vdd.n1496 vdd.n1495 9.3005
R1329 vdd.n1498 vdd.n1497 9.3005
R1330 vdd.n1500 vdd.n1499 9.3005
R1331 vdd.n1502 vdd.n1501 9.3005
R1332 vdd.n1504 vdd.n1503 9.3005
R1333 vdd.n1506 vdd.n1505 9.3005
R1334 vdd.n1508 vdd.n1507 9.3005
R1335 vdd.n1510 vdd.n1509 9.3005
R1336 vdd.n1512 vdd.n1511 9.3005
R1337 vdd.n1514 vdd.n1513 9.3005
R1338 vdd.n1516 vdd.n1515 9.3005
R1339 vdd.n1518 vdd.n1517 9.3005
R1340 vdd.n1520 vdd.n1519 9.3005
R1341 vdd.n1522 vdd.n1521 9.3005
R1342 vdd.n1524 vdd.n1523 9.3005
R1343 vdd.n1526 vdd.n1525 9.3005
R1344 vdd.n1528 vdd.n1527 9.3005
R1345 vdd.n1530 vdd.n1529 9.3005
R1346 vdd.n1532 vdd.n1531 9.3005
R1347 vdd.n1534 vdd.n1533 9.3005
R1348 vdd.n1536 vdd.n1535 9.3005
R1349 vdd.n1538 vdd.n1537 9.3005
R1350 vdd.n1540 vdd.n1539 9.3005
R1351 vdd.n1542 vdd.n1541 9.3005
R1352 vdd.n1544 vdd.n1543 9.3005
R1353 vdd.n1546 vdd.n1545 9.3005
R1354 vdd.n1548 vdd.n1547 9.3005
R1355 vdd.n1550 vdd.n1549 9.3005
R1356 vdd.n1552 vdd.n1551 9.3005
R1357 vdd.n1554 vdd.n1553 9.3005
R1358 vdd.n1556 vdd.n1555 9.3005
R1359 vdd.n1489 vdd.n1557 4.28224
R1360 vdd.n1488 vdd.n1492 0.15675
R1361 vdd.n1492 vdd.n1494 0.15675
R1362 vdd.n1494 vdd.n1496 0.15675
R1363 vdd.n1496 vdd.n1498 0.15675
R1364 vdd.n1498 vdd.n1500 0.15675
R1365 vdd.n1500 vdd.n1502 0.15675
R1366 vdd.n1502 vdd.n1504 0.15675
R1367 vdd.n1504 vdd.n1506 0.15675
R1368 vdd.n1506 vdd.n1508 0.15675
R1369 vdd.n1508 vdd.n1510 0.15675
R1370 vdd.n1510 vdd.n1512 0.15675
R1371 vdd.n1512 vdd.n1514 0.15675
R1372 vdd.n1514 vdd.n1516 0.15675
R1373 vdd.n1516 vdd.n1518 0.15675
R1374 vdd.n1518 vdd.n1520 0.15675
R1375 vdd.n1520 vdd.n1522 0.15675
R1376 vdd.n1522 vdd.n1524 0.15675
R1377 vdd.n1524 vdd.n1526 0.15675
R1378 vdd.n1526 vdd.n1528 0.15675
R1379 vdd.n1528 vdd.n1530 0.15675
R1380 vdd.n1530 vdd.n1532 0.15675
R1381 vdd.n1532 vdd.n1534 0.15675
R1382 vdd.n1534 vdd.n1536 0.15675
R1383 vdd.n1536 vdd.n1538 0.15675
R1384 vdd.n1538 vdd.n1540 0.15675
R1385 vdd.n1540 vdd.n1542 0.15675
R1386 vdd.n1542 vdd.n1544 0.15675
R1387 vdd.n1544 vdd.n1546 0.15675
R1388 vdd.n1546 vdd.n1548 0.15675
R1389 vdd.n1548 vdd.n1550 0.15675
R1390 vdd.n1550 vdd.n1552 0.15675
R1391 vdd.n1552 vdd.n1554 0.15675
R1392 vdd.n1554 vdd.n1556 0.15675
R1393 vdd.n1556 vdd.n1489 2.68753
R1394 vdd.n1489 vdd.n1558 189.355
R1395 vdd.n1560 vdd.n1559 185
R1396 vdd.n1557 vdd.n1560 185
R1397 vdd.n1562 vdd.n1561 185
R1398 vdd.n1555 vdd.n1562 185
R1399 vdd.n1564 vdd.n1563 185
R1400 vdd.n1553 vdd.n1564 185
R1401 vdd.n1566 vdd.n1565 185
R1402 vdd.n1551 vdd.n1566 185
R1403 vdd.n1568 vdd.n1567 185
R1404 vdd.n1549 vdd.n1568 185
R1405 vdd.n1570 vdd.n1569 185
R1406 vdd.n1547 vdd.n1570 185
R1407 vdd.n1572 vdd.n1571 185
R1408 vdd.n1545 vdd.n1572 185
R1409 vdd.n1574 vdd.n1573 185
R1410 vdd.n1543 vdd.n1574 185
R1411 vdd.n1576 vdd.n1575 185
R1412 vdd.n1541 vdd.n1576 185
R1413 vdd.n1578 vdd.n1577 185
R1414 vdd.n1539 vdd.n1578 185
R1415 vdd.n1580 vdd.n1579 185
R1416 vdd.n1537 vdd.n1580 185
R1417 vdd.n1582 vdd.n1581 185
R1418 vdd.n1535 vdd.n1582 185
R1419 vdd.n1584 vdd.n1583 185
R1420 vdd.n1533 vdd.n1584 185
R1421 vdd.n1586 vdd.n1585 185
R1422 vdd.n1531 vdd.n1586 185
R1423 vdd.n1588 vdd.n1587 185
R1424 vdd.n1529 vdd.n1588 185
R1425 vdd.n1590 vdd.n1589 185
R1426 vdd.n1527 vdd.n1590 185
R1427 vdd.n1592 vdd.n1591 185
R1428 vdd.n1525 vdd.n1592 185
R1429 vdd.n1594 vdd.n1593 185
R1430 vdd.n1523 vdd.n1594 185
R1431 vdd.n1596 vdd.n1595 185
R1432 vdd.n1521 vdd.n1596 185
R1433 vdd.n1598 vdd.n1597 185
R1434 vdd.n1519 vdd.n1598 185
R1435 vdd.n1600 vdd.n1599 185
R1436 vdd.n1517 vdd.n1600 185
R1437 vdd.n1602 vdd.n1601 185
R1438 vdd.n1515 vdd.n1602 185
R1439 vdd.n1604 vdd.n1603 185
R1440 vdd.n1513 vdd.n1604 185
R1441 vdd.n1606 vdd.n1605 185
R1442 vdd.n1511 vdd.n1606 185
R1443 vdd.n1608 vdd.n1607 185
R1444 vdd.n1509 vdd.n1608 185
R1445 vdd.n1610 vdd.n1609 185
R1446 vdd.n1507 vdd.n1610 185
R1447 vdd.n1612 vdd.n1611 185
R1448 vdd.n1505 vdd.n1612 185
R1449 vdd.n1614 vdd.n1613 185
R1450 vdd.n1503 vdd.n1614 185
R1451 vdd.n1616 vdd.n1615 185
R1452 vdd.n1501 vdd.n1616 185
R1453 vdd.n1618 vdd.n1617 185
R1454 vdd.n1499 vdd.n1618 185
R1455 vdd.n1620 vdd.n1619 185
R1456 vdd.n1497 vdd.n1620 185
R1457 vdd.n1622 vdd.n1621 185
R1458 vdd.n1495 vdd.n1622 185
R1459 vdd.n1624 vdd.n1623 185
R1460 vdd.n1493 vdd.n1624 185
R1461 vdd.n1626 vdd.n1625 185
R1462 vdd.n1491 vdd.n1626 185
R1463 vdd.n1490 vdd.n1731 185
R1464 vdd.n1490 vdd.n1491 16.0005
R1465 vdd.n1491 vdd.n1493 16.0005
R1466 vdd.n1493 vdd.n1495 16.0005
R1467 vdd.n1495 vdd.n1497 16.0005
R1468 vdd.n1497 vdd.n1499 16.0005
R1469 vdd.n1499 vdd.n1501 16.0005
R1470 vdd.n1501 vdd.n1503 16.0005
R1471 vdd.n1503 vdd.n1505 16.0005
R1472 vdd.n1505 vdd.n1507 16.0005
R1473 vdd.n1507 vdd.n1509 16.0005
R1474 vdd.n1509 vdd.n1511 16.0005
R1475 vdd.n1511 vdd.n1513 16.0005
R1476 vdd.n1513 vdd.n1515 16.0005
R1477 vdd.n1515 vdd.n1517 16.0005
R1478 vdd.n1517 vdd.n1519 16.0005
R1479 vdd.n1519 vdd.n1521 16.0005
R1480 vdd.n1521 vdd.n1523 16.0005
R1481 vdd.n1523 vdd.n1525 16.0005
R1482 vdd.n1525 vdd.n1527 16.0005
R1483 vdd.n1527 vdd.n1529 16.0005
R1484 vdd.n1529 vdd.n1531 16.0005
R1485 vdd.n1531 vdd.n1533 16.0005
R1486 vdd.n1533 vdd.n1535 16.0005
R1487 vdd.n1535 vdd.n1537 16.0005
R1488 vdd.n1537 vdd.n1539 16.0005
R1489 vdd.n1539 vdd.n1541 16.0005
R1490 vdd.n1541 vdd.n1543 16.0005
R1491 vdd.n1543 vdd.n1545 16.0005
R1492 vdd.n1545 vdd.n1547 16.0005
R1493 vdd.n1547 vdd.n1549 16.0005
R1494 vdd.n1549 vdd.n1551 16.0005
R1495 vdd.n1551 vdd.n1553 16.0005
R1496 vdd.n1553 vdd.n1555 16.0005
R1497 vdd.n1555 vdd.n1557 16.0005
R1498 vdd.n1731 vdd.n1626 114.001
R1499 vdd.n1626 vdd.n1624 114.001
R1500 vdd.n1624 vdd.n1622 114.001
R1501 vdd.n1622 vdd.n1620 114.001
R1502 vdd.n1620 vdd.n1618 114.001
R1503 vdd.n1618 vdd.n1616 114.001
R1504 vdd.n1616 vdd.n1614 114.001
R1505 vdd.n1614 vdd.n1612 114.001
R1506 vdd.n1612 vdd.n1610 114.001
R1507 vdd.n1610 vdd.n1608 114.001
R1508 vdd.n1608 vdd.n1606 114.001
R1509 vdd.n1606 vdd.n1604 114.001
R1510 vdd.n1604 vdd.n1602 114.001
R1511 vdd.n1602 vdd.n1600 114.001
R1512 vdd.n1600 vdd.n1598 114.001
R1513 vdd.n1598 vdd.n1596 114.001
R1514 vdd.n1596 vdd.n1594 114.001
R1515 vdd.n1594 vdd.n1592 114.001
R1516 vdd.n1592 vdd.n1590 114.001
R1517 vdd.n1590 vdd.n1588 114.001
R1518 vdd.n1588 vdd.n1586 114.001
R1519 vdd.n1586 vdd.n1584 114.001
R1520 vdd.n1584 vdd.n1582 114.001
R1521 vdd.n1582 vdd.n1580 114.001
R1522 vdd.n1580 vdd.n1578 114.001
R1523 vdd.n1578 vdd.n1576 114.001
R1524 vdd.n1576 vdd.n1574 114.001
R1525 vdd.n1574 vdd.n1572 114.001
R1526 vdd.n1572 vdd.n1570 114.001
R1527 vdd.n1570 vdd.n1568 114.001
R1528 vdd.n1568 vdd.n1566 114.001
R1529 vdd.n1566 vdd.n1564 114.001
R1530 vdd.n1564 vdd.n1562 114.001
R1531 vdd.n1562 vdd.n1560 114.001
R1532 vdd.n1560 vdd.n1558 114.001
R1533 vdd.n1627 vdd.n1628 185
R1534 vdd.n1629 vdd.n1630 185
R1535 vdd.n1630 vdd.n1631 185
R1536 vdd.n1632 vdd.n1633 185
R1537 vdd.n1633 vdd.n1634 185
R1538 vdd.n1635 vdd.n1636 185
R1539 vdd.n1636 vdd.n1637 185
R1540 vdd.n1638 vdd.n1639 185
R1541 vdd.n1643 vdd.n1644 185
R1542 vdd.n1645 vdd.n1646 185
R1543 vdd.n1646 vdd.n1647 185
R1544 vdd.n1648 vdd.n1649 185
R1545 vdd.n1649 vdd.n1650 185
R1546 vdd.n1651 vdd.n1652 185
R1547 vdd.n1652 vdd.n1653 185
R1548 vdd.n1654 vdd.n1655 185
R1549 vdd.n1655 vdd.n1656 185
R1550 vdd.n1657 vdd.n1658 185
R1551 vdd.n1658 vdd.n1659 185
R1552 vdd.n1660 vdd.n1661 185
R1553 vdd.n1661 vdd.n1662 185
R1554 vdd.n1663 vdd.n1664 185
R1555 vdd.n1664 vdd.n1665 185
R1556 vdd.n1666 vdd.n1667 185
R1557 vdd.n1675 vdd.n1676 185
R1558 vdd.n1677 vdd.n1678 185
R1559 vdd.n1678 vdd.n1679 185
R1560 vdd.n1680 vdd.n1681 185
R1561 vdd.n1681 vdd.n1682 185
R1562 vdd.n1683 vdd.n1684 185
R1563 vdd.n1684 vdd.n1685 185
R1564 vdd.n1686 vdd.n1687 185
R1565 vdd.n1687 vdd.n1688 185
R1566 vdd.n1689 vdd.n1690 185
R1567 vdd.n1690 vdd.n1691 185
R1568 vdd.n1692 vdd.n1693 185
R1569 vdd.n1693 vdd.n1694 185
R1570 vdd.n1695 vdd.n1696 185
R1571 vdd.n1696 vdd.n1697 185
R1572 vdd.n1698 vdd.n1699 185
R1573 vdd.n1699 vdd.n1700 185
R1574 vdd.n1701 vdd.n1702 185
R1575 vdd.n1702 vdd.n1703 185
R1576 vdd.n1704 vdd.n1705 185
R1577 vdd.n1705 vdd.n1706 185
R1578 vdd.n1707 vdd.n1708 185
R1579 vdd.n1708 vdd.n1709 185
R1580 vdd.n1710 vdd.n1711 185
R1581 vdd.n1711 vdd.n1712 185
R1582 vdd.n1713 vdd.n1714 185
R1583 vdd.n1714 vdd.n1715 185
R1584 vdd.n1716 vdd.n1717 185
R1585 vdd.n1731 vdd.n1716 187.927
R1586 vdd.n1716 vdd.n1625 16.5816
R1587 vdd.n1625 vdd.n1713 2.92658
R1588 vdd.n1713 vdd.n1623 16.5816
R1589 vdd.n1623 vdd.n1710 2.92658
R1590 vdd.n1710 vdd.n1621 16.5816
R1591 vdd.n1621 vdd.n1707 2.92658
R1592 vdd.n1707 vdd.n1619 16.5816
R1593 vdd.n1619 vdd.n1704 2.92658
R1594 vdd.n1704 vdd.n1617 16.5816
R1595 vdd.n1617 vdd.t29 1.95122
R1596 vdd.t29 vdd.n1701 0.975859
R1597 vdd.n1701 vdd.n1615 16.5816
R1598 vdd.n1615 vdd.n1698 2.92658
R1599 vdd.n1698 vdd.n1613 16.5816
R1600 vdd.n1613 vdd.n1695 2.92658
R1601 vdd.n1695 vdd.n1611 16.5816
R1602 vdd.n1611 vdd.n1692 2.92658
R1603 vdd.n1692 vdd.n1609 16.5816
R1604 vdd.n1609 vdd.n1689 2.92658
R1605 vdd.n1689 vdd.n1607 16.5816
R1606 vdd.n1607 vdd.n1686 2.92658
R1607 vdd.n1686 vdd.n1605 16.5816
R1608 vdd.n1605 vdd.n1683 2.92658
R1609 vdd.n1683 vdd.n1603 16.5816
R1610 vdd.n1603 vdd.n1680 2.92658
R1611 vdd.n1680 vdd.n1601 16.5816
R1612 vdd.n1601 vdd.n1677 2.92658
R1613 vdd.n1677 vdd.t6 2.92658
R1614 vdd.t6 vdd.n1599 13.6555
R1615 vdd.n1599 vdd.n1675 2.92658
R1616 vdd.n1675 vdd.n1597 16.5816
R1617 vdd.n1597 vdd.n1595 19.5077
R1618 vdd.n1595 vdd.n1593 19.5077
R1619 vdd.n1593 vdd.n1591 19.5077
R1620 vdd.n1591 vdd.n1666 11.7048
R1621 vdd.n1589 vdd.n1666 7.80337
R1622 vdd.n1589 vdd.t7 9.75409
R1623 vdd.t7 vdd.n1663 1.95122
R1624 vdd.n1587 vdd.n1663 7.80337
R1625 vdd.n1587 vdd.n1660 11.7048
R1626 vdd.n1585 vdd.n1660 7.80337
R1627 vdd.n1585 vdd.n1657 11.7048
R1628 vdd.n1583 vdd.n1657 7.80337
R1629 vdd.n1583 vdd.n1654 11.7048
R1630 vdd.n1581 vdd.n1654 7.80337
R1631 vdd.n1581 vdd.n1651 11.7048
R1632 vdd.n1579 vdd.n1651 7.80337
R1633 vdd.n1579 vdd.n1648 11.7048
R1634 vdd.n1577 vdd.n1648 7.80337
R1635 vdd.n1577 vdd.n1645 11.7048
R1636 vdd.t37 vdd.n1645 1.95122
R1637 vdd.n1575 vdd.t37 5.85266
R1638 vdd.n1575 vdd.n1643 11.7048
R1639 vdd.n1573 vdd.n1643 7.80337
R1640 vdd.n1573 vdd.n1571 19.5077
R1641 vdd.n1571 vdd.n1569 19.5077
R1642 vdd.n1569 vdd.n1567 19.5077
R1643 vdd.n1567 vdd.n1638 18.5323
R1644 vdd.n1565 vdd.n1638 0.975859
R1645 vdd.n1565 vdd.t38 17.557
R1646 vdd.n1635 vdd.t38 0.975859
R1647 vdd.n1563 vdd.n1635 0.975859
R1648 vdd.n1563 vdd.n1632 18.5323
R1649 vdd.n1561 vdd.n1632 0.975859
R1650 vdd.n1561 vdd.n1629 18.5323
R1651 vdd.n1559 vdd.n1629 0.975859
R1652 vdd.n1559 vdd.n1627 18.5323
R1653 vdd.n1558 vdd.n1627 185.976
R1654 vdd.n1715 vdd.n1719 4.28224
R1655 vdd.n1712 vdd.n1720 9.3005
R1656 vdd.n1709 vdd.n1721 9.3005
R1657 vdd.n1706 vdd.n1722 9.3005
R1658 vdd.n1703 vdd.n1723 9.3005
R1659 vdd.n1700 vdd.n1724 9.3005
R1660 vdd.n1697 vdd.n1725 9.3005
R1661 vdd.n1694 vdd.n1726 9.3005
R1662 vdd.n1691 vdd.n1727 9.3005
R1663 vdd.n1688 vdd.n1728 9.3005
R1664 vdd.n1685 vdd.n1729 9.3005
R1665 vdd.n1682 vdd.n1730 9.3005
R1666 vdd.n1679 vdd.n1718 4.28224
R1667 vdd.n1717 vdd.n1719 189.355
R1668 vdd.n1715 vdd.n1712 16.0005
R1669 vdd.n1712 vdd.n1709 16.0005
R1670 vdd.n1709 vdd.n1706 16.0005
R1671 vdd.n1706 vdd.n1703 16.0005
R1672 vdd.n1703 vdd.n1700 16.0005
R1673 vdd.n1700 vdd.n1697 16.0005
R1674 vdd.n1697 vdd.n1694 16.0005
R1675 vdd.n1694 vdd.n1691 16.0005
R1676 vdd.n1691 vdd.n1688 16.0005
R1677 vdd.n1688 vdd.n1685 16.0005
R1678 vdd.n1685 vdd.n1682 16.0005
R1679 vdd.n1682 vdd.n1679 16.0005
R1680 vdd.n1718 vdd.n1676 189.355
R1681 vdd.n1719 vdd.n1720 2.68753
R1682 vdd.n1720 vdd.n1721 0.15675
R1683 vdd.n1721 vdd.n1722 0.15675
R1684 vdd.n1722 vdd.n1723 0.15675
R1685 vdd.n1723 vdd.n1724 0.15675
R1686 vdd.n1724 vdd.n1725 0.15675
R1687 vdd.n1725 vdd.n1726 0.15675
R1688 vdd.n1726 vdd.n1727 0.15675
R1689 vdd.n1727 vdd.n1728 0.15675
R1690 vdd.n1728 vdd.n1729 0.15675
R1691 vdd.n1729 vdd.n1730 0.15675
R1692 vdd.n1730 vdd.n1718 2.68753
R1693 vdd.n1717 vdd.n1714 114.001
R1694 vdd.n1714 vdd.n1711 114.001
R1695 vdd.n1711 vdd.n1708 114.001
R1696 vdd.n1708 vdd.n1705 114.001
R1697 vdd.n1705 vdd.n1702 114.001
R1698 vdd.n1702 vdd.n1699 114.001
R1699 vdd.n1699 vdd.n1696 114.001
R1700 vdd.n1696 vdd.n1693 114.001
R1701 vdd.n1693 vdd.n1690 114.001
R1702 vdd.n1690 vdd.n1687 114.001
R1703 vdd.n1687 vdd.n1684 114.001
R1704 vdd.n1684 vdd.n1681 114.001
R1705 vdd.n1681 vdd.n1678 114.001
R1706 vdd.n1678 vdd.n1676 114.001
R1707 vdd.n1676 vdd.n1667 507.3
R1708 vdd.n1667 vdd.n1664 114.001
R1709 vdd.n1664 vdd.n1661 114.001
R1710 vdd.n1661 vdd.n1658 114.001
R1711 vdd.n1658 vdd.n1655 114.001
R1712 vdd.n1655 vdd.n1652 114.001
R1713 vdd.n1652 vdd.n1649 114.001
R1714 vdd.n1649 vdd.n1646 114.001
R1715 vdd.n1646 vdd.n1644 114.001
R1716 vdd.n1644 vdd.n1639 495.901
R1717 vdd.n1639 vdd.n1636 114.001
R1718 vdd.n1636 vdd.n1633 114.001
R1719 vdd.n1633 vdd.n1630 114.001
R1720 vdd.n1630 vdd.n1628 114.001
R1721 vdd.n1665 vdd.n1669 4.28224
R1722 vdd.n1662 vdd.n1670 9.3005
R1723 vdd.n1659 vdd.n1671 9.3005
R1724 vdd.n1656 vdd.n1672 9.3005
R1725 vdd.n1653 vdd.n1673 9.3005
R1726 vdd.n1650 vdd.n1674 9.3005
R1727 vdd.n1647 vdd.n1668 4.28224
R1728 vdd.n1667 vdd.n1669 189.355
R1729 vdd.n1665 vdd.n1662 16.0005
R1730 vdd.n1662 vdd.n1659 16.0005
R1731 vdd.n1659 vdd.n1656 16.0005
R1732 vdd.n1656 vdd.n1653 16.0005
R1733 vdd.n1653 vdd.n1650 16.0005
R1734 vdd.n1650 vdd.n1647 16.0005
R1735 vdd.n1668 vdd.n1644 189.355
R1736 vdd.n1669 vdd.n1670 2.68753
R1737 vdd.n1670 vdd.n1671 0.15675
R1738 vdd.n1671 vdd.n1672 0.15675
R1739 vdd.n1672 vdd.n1673 0.15675
R1740 vdd.n1673 vdd.n1674 0.15675
R1741 vdd.n1674 vdd.n1668 2.68753
R1742 vdd.n1637 vdd.n1641 4.28224
R1743 vdd.n1634 vdd.n1642 9.3005
R1744 vdd.n1631 vdd.n1640 4.28224
R1745 vdd.n1639 vdd.n1641 189.355
R1746 vdd.n1637 vdd.n1634 16.0005
R1747 vdd.n1634 vdd.n1631 16.0005
R1748 vdd.n1640 vdd.n1628 189.355
R1749 vdd.n1641 vdd.n1642 2.68753
R1750 vdd.n1640 vdd.n1642 2.68753
R1751 vdd.n1488 vdd.t30 29.1857
R1752 vdd.n1732 vdd.n1198 13.7566
R1753 vdd.n1200 vdd.n1201 4.28224
R1754 vdd.n1203 vdd.n1202 9.3005
R1755 vdd.n1205 vdd.n1204 9.3005
R1756 vdd.n1207 vdd.n1206 9.3005
R1757 vdd.n1209 vdd.n1208 9.3005
R1758 vdd.n1211 vdd.n1210 9.3005
R1759 vdd.n1213 vdd.n1212 9.3005
R1760 vdd.n1215 vdd.n1214 9.3005
R1761 vdd.n1217 vdd.n1216 9.3005
R1762 vdd.n1219 vdd.n1218 9.3005
R1763 vdd.n1221 vdd.n1220 9.3005
R1764 vdd.n1223 vdd.n1222 9.3005
R1765 vdd.n1225 vdd.n1224 9.3005
R1766 vdd.n1227 vdd.n1226 9.3005
R1767 vdd.n1229 vdd.n1228 9.3005
R1768 vdd.n1231 vdd.n1230 9.3005
R1769 vdd.n1233 vdd.n1232 9.3005
R1770 vdd.n1235 vdd.n1234 9.3005
R1771 vdd.n1237 vdd.n1236 9.3005
R1772 vdd.n1239 vdd.n1238 9.3005
R1773 vdd.n1241 vdd.n1240 9.3005
R1774 vdd.n1243 vdd.n1242 9.3005
R1775 vdd.n1245 vdd.n1244 9.3005
R1776 vdd.n1247 vdd.n1246 9.3005
R1777 vdd.n1249 vdd.n1248 9.3005
R1778 vdd.n1251 vdd.n1250 9.3005
R1779 vdd.n1253 vdd.n1252 9.3005
R1780 vdd.n1255 vdd.n1254 9.3005
R1781 vdd.n1257 vdd.n1256 9.3005
R1782 vdd.n1259 vdd.n1258 9.3005
R1783 vdd.n1261 vdd.n1260 9.3005
R1784 vdd.n1263 vdd.n1262 9.3005
R1785 vdd.n1265 vdd.n1264 9.3005
R1786 vdd.n1267 vdd.n1266 9.3005
R1787 vdd.n1269 vdd.n1268 9.3005
R1788 vdd.n1271 vdd.n1270 9.3005
R1789 vdd.n1273 vdd.n1272 9.3005
R1790 vdd.n1275 vdd.n1274 9.3005
R1791 vdd.n1277 vdd.n1276 9.3005
R1792 vdd.n1279 vdd.n1278 9.3005
R1793 vdd.n1199 vdd.n1280 4.28224
R1794 vdd.n1203 vdd.n1200 2.68753
R1795 vdd.n1205 vdd.n1203 0.15675
R1796 vdd.n1207 vdd.n1205 0.15675
R1797 vdd.n1209 vdd.n1207 0.15675
R1798 vdd.n1211 vdd.n1209 0.15675
R1799 vdd.n1213 vdd.n1211 0.15675
R1800 vdd.n1198 vdd.n1213 0.0426875
R1801 vdd.n1198 vdd.n1215 0.114563
R1802 vdd.n1215 vdd.n1217 0.15675
R1803 vdd.n1217 vdd.n1219 0.15675
R1804 vdd.n1219 vdd.n1221 0.15675
R1805 vdd.n1221 vdd.n1223 0.15675
R1806 vdd.n1223 vdd.n1225 0.15675
R1807 vdd.n1225 vdd.n1227 0.15675
R1808 vdd.n1227 vdd.n1229 0.15675
R1809 vdd.n1229 vdd.n1231 0.15675
R1810 vdd.n1231 vdd.n1233 0.15675
R1811 vdd.n1233 vdd.n1235 0.15675
R1812 vdd.n1235 vdd.n1237 0.15675
R1813 vdd.n1237 vdd.n1239 0.15675
R1814 vdd.n1239 vdd.n1241 0.15675
R1815 vdd.n1241 vdd.n1243 0.15675
R1816 vdd.n1243 vdd.n1245 0.15675
R1817 vdd.n1245 vdd.n1247 0.15675
R1818 vdd.n1247 vdd.n1249 0.15675
R1819 vdd.n1249 vdd.n1251 0.15675
R1820 vdd.n1251 vdd.n1253 0.15675
R1821 vdd.n1253 vdd.n1255 0.15675
R1822 vdd.n1255 vdd.n1257 0.15675
R1823 vdd.n1257 vdd.n1259 0.15675
R1824 vdd.n1259 vdd.n1261 0.15675
R1825 vdd.n1261 vdd.n1263 0.15675
R1826 vdd.n1263 vdd.n1265 0.15675
R1827 vdd.n1265 vdd.n1267 0.15675
R1828 vdd.n1267 vdd.n1269 0.15675
R1829 vdd.n1269 vdd.n1271 0.15675
R1830 vdd.n1271 vdd.n1273 0.15675
R1831 vdd.n1273 vdd.n1275 0.15675
R1832 vdd.n1275 vdd.n1277 0.15675
R1833 vdd.n1277 vdd.n1279 0.15675
R1834 vdd.n1279 vdd.n1199 2.68753
R1835 vdd.n1199 vdd.n1282 189.355
R1836 vdd.n1284 vdd.n1283 185
R1837 vdd.n1280 vdd.n1284 185
R1838 vdd.n1286 vdd.n1285 185
R1839 vdd.n1278 vdd.n1286 185
R1840 vdd.n1288 vdd.n1287 185
R1841 vdd.n1276 vdd.n1288 185
R1842 vdd.n1290 vdd.n1289 185
R1843 vdd.n1274 vdd.n1290 185
R1844 vdd.n1292 vdd.n1291 185
R1845 vdd.n1272 vdd.n1292 185
R1846 vdd.n1294 vdd.n1293 185
R1847 vdd.n1270 vdd.n1294 185
R1848 vdd.n1296 vdd.n1295 185
R1849 vdd.n1268 vdd.n1296 185
R1850 vdd.n1298 vdd.n1297 185
R1851 vdd.n1266 vdd.n1298 185
R1852 vdd.n1300 vdd.n1299 185
R1853 vdd.n1264 vdd.n1300 185
R1854 vdd.n1302 vdd.n1301 185
R1855 vdd.n1262 vdd.n1302 185
R1856 vdd.n1304 vdd.n1303 185
R1857 vdd.n1260 vdd.n1304 185
R1858 vdd.n1306 vdd.n1305 185
R1859 vdd.n1258 vdd.n1306 185
R1860 vdd.n1308 vdd.n1307 185
R1861 vdd.n1256 vdd.n1308 185
R1862 vdd.n1310 vdd.n1309 185
R1863 vdd.n1254 vdd.n1310 185
R1864 vdd.n1312 vdd.n1311 185
R1865 vdd.n1252 vdd.n1312 185
R1866 vdd.n1314 vdd.n1313 185
R1867 vdd.n1250 vdd.n1314 185
R1868 vdd.n1316 vdd.n1315 185
R1869 vdd.n1248 vdd.n1316 185
R1870 vdd.n1318 vdd.n1317 185
R1871 vdd.n1246 vdd.n1318 185
R1872 vdd.n1320 vdd.n1319 185
R1873 vdd.n1244 vdd.n1320 185
R1874 vdd.n1322 vdd.n1321 185
R1875 vdd.n1242 vdd.n1322 185
R1876 vdd.n1324 vdd.n1323 185
R1877 vdd.n1240 vdd.n1324 185
R1878 vdd.n1326 vdd.n1325 185
R1879 vdd.n1238 vdd.n1326 185
R1880 vdd.n1328 vdd.n1327 185
R1881 vdd.n1236 vdd.n1328 185
R1882 vdd.n1330 vdd.n1329 185
R1883 vdd.n1234 vdd.n1330 185
R1884 vdd.n1332 vdd.n1331 185
R1885 vdd.n1232 vdd.n1332 185
R1886 vdd.n1334 vdd.n1333 185
R1887 vdd.n1230 vdd.n1334 185
R1888 vdd.n1336 vdd.n1335 185
R1889 vdd.n1228 vdd.n1336 185
R1890 vdd.n1338 vdd.n1337 185
R1891 vdd.n1226 vdd.n1338 185
R1892 vdd.n1340 vdd.n1339 185
R1893 vdd.n1224 vdd.n1340 185
R1894 vdd.n1342 vdd.n1341 185
R1895 vdd.n1222 vdd.n1342 185
R1896 vdd.n1344 vdd.n1343 185
R1897 vdd.n1220 vdd.n1344 185
R1898 vdd.n1346 vdd.n1345 185
R1899 vdd.n1218 vdd.n1346 185
R1900 vdd.n1348 vdd.n1347 185
R1901 vdd.n1216 vdd.n1348 185
R1902 vdd.n1350 vdd.n1349 185
R1903 vdd.n1214 vdd.n1350 185
R1904 vdd.n1352 vdd.n1351 185
R1905 vdd.n1212 vdd.n1352 185
R1906 vdd.n1354 vdd.n1353 185
R1907 vdd.n1210 vdd.n1354 185
R1908 vdd.n1356 vdd.n1355 185
R1909 vdd.n1208 vdd.n1356 185
R1910 vdd.n1358 vdd.n1357 185
R1911 vdd.n1206 vdd.n1358 185
R1912 vdd.n1360 vdd.n1359 185
R1913 vdd.n1204 vdd.n1360 185
R1914 vdd.n1362 vdd.n1361 185
R1915 vdd.n1202 vdd.n1362 185
R1916 vdd.n1364 vdd.n1363 185
R1917 vdd.n1201 vdd.n1364 185
R1918 vdd.n1487 vdd.n1486 185
R1919 vdd.n1200 vdd.n1487 189.355
R1920 vdd.n1201 vdd.n1202 16.0005
R1921 vdd.n1202 vdd.n1204 16.0005
R1922 vdd.n1204 vdd.n1206 16.0005
R1923 vdd.n1206 vdd.n1208 16.0005
R1924 vdd.n1208 vdd.n1210 16.0005
R1925 vdd.n1210 vdd.n1212 16.0005
R1926 vdd.n1212 vdd.n1214 16.0005
R1927 vdd.n1214 vdd.n1216 16.0005
R1928 vdd.n1216 vdd.n1218 16.0005
R1929 vdd.n1218 vdd.n1220 16.0005
R1930 vdd.n1220 vdd.n1222 16.0005
R1931 vdd.n1222 vdd.n1224 16.0005
R1932 vdd.n1224 vdd.n1226 16.0005
R1933 vdd.n1226 vdd.n1228 16.0005
R1934 vdd.n1228 vdd.n1230 16.0005
R1935 vdd.n1230 vdd.n1232 16.0005
R1936 vdd.n1232 vdd.n1234 16.0005
R1937 vdd.n1234 vdd.n1236 16.0005
R1938 vdd.n1236 vdd.n1238 16.0005
R1939 vdd.n1238 vdd.n1240 16.0005
R1940 vdd.n1240 vdd.n1242 16.0005
R1941 vdd.n1242 vdd.n1244 16.0005
R1942 vdd.n1244 vdd.n1246 16.0005
R1943 vdd.n1246 vdd.n1248 16.0005
R1944 vdd.n1248 vdd.n1250 16.0005
R1945 vdd.n1250 vdd.n1252 16.0005
R1946 vdd.n1252 vdd.n1254 16.0005
R1947 vdd.n1254 vdd.n1256 16.0005
R1948 vdd.n1256 vdd.n1258 16.0005
R1949 vdd.n1258 vdd.n1260 16.0005
R1950 vdd.n1260 vdd.n1262 16.0005
R1951 vdd.n1262 vdd.n1264 16.0005
R1952 vdd.n1264 vdd.n1266 16.0005
R1953 vdd.n1266 vdd.n1268 16.0005
R1954 vdd.n1268 vdd.n1270 16.0005
R1955 vdd.n1270 vdd.n1272 16.0005
R1956 vdd.n1272 vdd.n1274 16.0005
R1957 vdd.n1274 vdd.n1276 16.0005
R1958 vdd.n1276 vdd.n1278 16.0005
R1959 vdd.n1278 vdd.n1280 16.0005
R1960 vdd.n1487 vdd.n1364 114.001
R1961 vdd.n1364 vdd.n1362 114.001
R1962 vdd.n1362 vdd.n1360 114.001
R1963 vdd.n1360 vdd.n1358 114.001
R1964 vdd.n1358 vdd.n1356 114.001
R1965 vdd.n1356 vdd.n1354 114.001
R1966 vdd.n1354 vdd.n1352 114.001
R1967 vdd.n1352 vdd.n1350 114.001
R1968 vdd.n1350 vdd.n1348 114.001
R1969 vdd.n1348 vdd.n1346 114.001
R1970 vdd.n1346 vdd.n1344 114.001
R1971 vdd.n1344 vdd.n1342 114.001
R1972 vdd.n1342 vdd.n1340 114.001
R1973 vdd.n1340 vdd.n1338 114.001
R1974 vdd.n1338 vdd.n1336 114.001
R1975 vdd.n1336 vdd.n1334 114.001
R1976 vdd.n1334 vdd.n1332 114.001
R1977 vdd.n1332 vdd.n1330 114.001
R1978 vdd.n1330 vdd.n1328 114.001
R1979 vdd.n1328 vdd.n1326 114.001
R1980 vdd.n1326 vdd.n1324 114.001
R1981 vdd.n1324 vdd.n1322 114.001
R1982 vdd.n1322 vdd.n1320 114.001
R1983 vdd.n1320 vdd.n1318 114.001
R1984 vdd.n1318 vdd.n1316 114.001
R1985 vdd.n1316 vdd.n1314 114.001
R1986 vdd.n1314 vdd.n1312 114.001
R1987 vdd.n1312 vdd.n1310 114.001
R1988 vdd.n1310 vdd.n1308 114.001
R1989 vdd.n1308 vdd.n1306 114.001
R1990 vdd.n1306 vdd.n1304 114.001
R1991 vdd.n1304 vdd.n1302 114.001
R1992 vdd.n1302 vdd.n1300 114.001
R1993 vdd.n1300 vdd.n1298 114.001
R1994 vdd.n1298 vdd.n1296 114.001
R1995 vdd.n1296 vdd.n1294 114.001
R1996 vdd.n1294 vdd.n1292 114.001
R1997 vdd.n1292 vdd.n1290 114.001
R1998 vdd.n1290 vdd.n1288 114.001
R1999 vdd.n1288 vdd.n1286 114.001
R2000 vdd.n1286 vdd.n1284 114.001
R2001 vdd.n1284 vdd.n1282 114.001
R2002 vdd.n1365 vdd.n1366 185
R2003 vdd.n1367 vdd.n1368 185
R2004 vdd.n1369 vdd.n1370 185
R2005 vdd.n1370 vdd.n1371 185
R2006 vdd.n1372 vdd.n1373 185
R2007 vdd.n1373 vdd.n1374 185
R2008 vdd.n1375 vdd.n1376 185
R2009 vdd.n1376 vdd.n1377 185
R2010 vdd.n1378 vdd.n1379 185
R2011 vdd.n1379 vdd.n1380 185
R2012 vdd.n1381 vdd.n1382 185
R2013 vdd.n1382 vdd.n1383 185
R2014 vdd.n1384 vdd.n1385 185
R2015 vdd.n1385 vdd.n1386 185
R2016 vdd.n1387 vdd.n1388 185
R2017 vdd.n1388 vdd.n1389 185
R2018 vdd.n1390 vdd.n1391 185
R2019 vdd.n1399 vdd.n1400 185
R2020 vdd.n1401 vdd.n1402 185
R2021 vdd.n1402 vdd.n1403 185
R2022 vdd.n1404 vdd.n1405 185
R2023 vdd.n1405 vdd.n1406 185
R2024 vdd.n1407 vdd.n1408 185
R2025 vdd.n1408 vdd.n1409 185
R2026 vdd.n1410 vdd.n1411 185
R2027 vdd.n1411 vdd.n1412 185
R2028 vdd.n1413 vdd.n1414 185
R2029 vdd.n1414 vdd.n1415 185
R2030 vdd.n1416 vdd.n1417 185
R2031 vdd.n1417 vdd.n1418 185
R2032 vdd.n1419 vdd.n1420 185
R2033 vdd.n1420 vdd.n1421 185
R2034 vdd.n1422 vdd.n1423 185
R2035 vdd.n1423 vdd.n1424 185
R2036 vdd.n1425 vdd.n1426 185
R2037 vdd.n1426 vdd.n1427 185
R2038 vdd.n1428 vdd.n1429 185
R2039 vdd.n1429 vdd.n1430 185
R2040 vdd.n1431 vdd.n1432 185
R2041 vdd.n1432 vdd.n1433 185
R2042 vdd.n1434 vdd.n1435 185
R2043 vdd.n1435 vdd.n1436 185
R2044 vdd.n1437 vdd.n1438 185
R2045 vdd.n1438 vdd.n1439 185
R2046 vdd.n1440 vdd.n1441 185
R2047 vdd.n1441 vdd.n1442 185
R2048 vdd.n1443 vdd.n1444 185
R2049 vdd.n1444 vdd.n1445 185
R2050 vdd.n1446 vdd.n1447 185
R2051 vdd.n1447 vdd.n1448 185
R2052 vdd.n1449 vdd.n1450 185
R2053 vdd.n1450 vdd.n1451 185
R2054 vdd.n1452 vdd.n1453 185
R2055 vdd.n1453 vdd.n1454 185
R2056 vdd.n1455 vdd.n1456 185
R2057 vdd.n1456 vdd.n1457 185
R2058 vdd.n1458 vdd.n1459 185
R2059 vdd.n1459 vdd.n1460 185
R2060 vdd.n1461 vdd.n1462 185
R2061 vdd.n1462 vdd.n1463 185
R2062 vdd.n1486 vdd.n1464 191.773
R2063 vdd.n1486 vdd.n1461 12.5769
R2064 vdd.n1363 vdd.n1461 6.77239
R2065 vdd.n1363 vdd.n1458 12.5769
R2066 vdd.n1361 vdd.n1458 6.77239
R2067 vdd.n1361 vdd.n1455 12.5769
R2068 vdd.n1359 vdd.n1455 6.77239
R2069 vdd.n1359 vdd.t19 9.67464
R2070 vdd.n1452 vdd.t19 2.90274
R2071 vdd.n1357 vdd.n1452 6.77239
R2072 vdd.n1357 vdd.n1449 12.5769
R2073 vdd.n1355 vdd.n1449 6.77239
R2074 vdd.n1355 vdd.n1446 12.5769
R2075 vdd.n1353 vdd.n1446 6.77239
R2076 vdd.n1353 vdd.n1443 12.5769
R2077 vdd.n1351 vdd.n1443 6.77239
R2078 vdd.n1351 vdd.n1440 12.5769
R2079 vdd.n1349 vdd.n1440 6.77239
R2080 vdd.n1349 vdd.n1437 12.5769
R2081 vdd.n1347 vdd.n1437 6.77239
R2082 vdd.n1347 vdd.n1434 12.5769
R2083 vdd.n1345 vdd.n1434 6.77239
R2084 vdd.n1345 vdd.n1431 12.5769
R2085 vdd.n1343 vdd.n1431 6.77239
R2086 vdd.n1343 vdd.n1428 12.5769
R2087 vdd.n1341 vdd.n1428 6.77239
R2088 vdd.n1341 vdd.t27 7.15936
R2089 vdd.t27 vdd.n1425 5.41802
R2090 vdd.n1339 vdd.n1425 6.77239
R2091 vdd.n1339 vdd.n1422 12.5769
R2092 vdd.n1337 vdd.n1422 6.77239
R2093 vdd.n1337 vdd.n1419 12.5769
R2094 vdd.n1335 vdd.n1419 6.77239
R2095 vdd.n1335 vdd.n1416 12.5769
R2096 vdd.n1333 vdd.n1416 6.77239
R2097 vdd.n1333 vdd.n1413 12.5769
R2098 vdd.n1331 vdd.n1413 6.77239
R2099 vdd.n1331 vdd.n1410 12.5769
R2100 vdd.n1329 vdd.n1410 6.77239
R2101 vdd.n1329 vdd.n1407 12.5769
R2102 vdd.n1327 vdd.n1407 6.77239
R2103 vdd.n1327 vdd.n1404 12.5769
R2104 vdd.n1325 vdd.n1404 6.77239
R2105 vdd.n1325 vdd.t31 11.029
R2106 vdd.n1401 vdd.t31 1.54836
R2107 vdd.n1323 vdd.n1401 6.77239
R2108 vdd.n1323 vdd.n1399 12.5769
R2109 vdd.n1321 vdd.n1399 6.77239
R2110 vdd.n1321 vdd.n1319 19.3488
R2111 vdd.n1319 vdd.n1317 19.3488
R2112 vdd.n1317 vdd.n1315 19.3488
R2113 vdd.n1315 vdd.n1390 16.8335
R2114 vdd.n1313 vdd.n1390 2.51578
R2115 vdd.n1313 vdd.t32 14.8987
R2116 vdd.n1387 vdd.t32 1.93533
R2117 vdd.n1311 vdd.n1387 2.51578
R2118 vdd.n1311 vdd.n1384 16.8335
R2119 vdd.n1309 vdd.n1384 2.51578
R2120 vdd.n1309 vdd.n1381 16.8335
R2121 vdd.n1307 vdd.n1381 2.51578
R2122 vdd.n1307 vdd.n1378 16.8335
R2123 vdd.n1305 vdd.n1378 2.51578
R2124 vdd.n1305 vdd.n1375 16.8335
R2125 vdd.n1303 vdd.n1375 2.51578
R2126 vdd.n1303 vdd.n1372 16.8335
R2127 vdd.n1301 vdd.n1372 2.51578
R2128 vdd.n1301 vdd.n1369 16.8335
R2129 vdd.t39 vdd.n1369 1.93533
R2130 vdd.n1299 vdd.t39 0.580948
R2131 vdd.n1299 vdd.n1367 16.8335
R2132 vdd.n1297 vdd.n1367 2.51578
R2133 vdd.n1297 vdd.n1295 19.3488
R2134 vdd.n1295 vdd.n1293 19.3488
R2135 vdd.n1293 vdd.n1291 19.3488
R2136 vdd.n1291 vdd.n1365 17.4139
R2137 vdd.n1289 vdd.n1365 1.93533
R2138 vdd.n1289 vdd.n1287 19.3488
R2139 vdd.n1287 vdd.t40 3.28971
R2140 vdd.t40 vdd.n1285 16.0596
R2141 vdd.n1285 vdd.n1283 19.3488
R2142 vdd.n1283 vdd.n1281 18.5202
R2143 vdd.n1282 vdd.n1281 185.827
R2144 vdd.n1463 vdd.n1466 4.28224
R2145 vdd.n1460 vdd.n1467 9.3005
R2146 vdd.n1457 vdd.n1468 9.3005
R2147 vdd.n1454 vdd.n1469 9.3005
R2148 vdd.n1451 vdd.n1470 9.3005
R2149 vdd.n1448 vdd.n1471 9.3005
R2150 vdd.n1445 vdd.n1472 9.3005
R2151 vdd.n1442 vdd.n1473 9.3005
R2152 vdd.n1439 vdd.n1474 9.3005
R2153 vdd.n1436 vdd.n1475 9.3005
R2154 vdd.n1433 vdd.n1476 9.3005
R2155 vdd.n1430 vdd.n1477 9.3005
R2156 vdd.n1427 vdd.n1478 9.3005
R2157 vdd.n1424 vdd.n1479 9.3005
R2158 vdd.n1421 vdd.n1480 9.3005
R2159 vdd.n1418 vdd.n1481 9.3005
R2160 vdd.n1415 vdd.n1482 9.3005
R2161 vdd.n1412 vdd.n1483 9.3005
R2162 vdd.n1409 vdd.n1484 9.3005
R2163 vdd.n1406 vdd.n1485 9.3005
R2164 vdd.n1403 vdd.n1465 4.28224
R2165 vdd.n1464 vdd.n1466 189.355
R2166 vdd.n1463 vdd.n1460 16.0005
R2167 vdd.n1460 vdd.n1457 16.0005
R2168 vdd.n1457 vdd.n1454 16.0005
R2169 vdd.n1454 vdd.n1451 16.0005
R2170 vdd.n1451 vdd.n1448 16.0005
R2171 vdd.n1448 vdd.n1445 16.0005
R2172 vdd.n1445 vdd.n1442 16.0005
R2173 vdd.n1442 vdd.n1439 16.0005
R2174 vdd.n1439 vdd.n1436 16.0005
R2175 vdd.n1436 vdd.n1433 16.0005
R2176 vdd.n1433 vdd.n1430 16.0005
R2177 vdd.n1430 vdd.n1427 16.0005
R2178 vdd.n1427 vdd.n1424 16.0005
R2179 vdd.n1424 vdd.n1421 16.0005
R2180 vdd.n1421 vdd.n1418 16.0005
R2181 vdd.n1418 vdd.n1415 16.0005
R2182 vdd.n1415 vdd.n1412 16.0005
R2183 vdd.n1412 vdd.n1409 16.0005
R2184 vdd.n1409 vdd.n1406 16.0005
R2185 vdd.n1406 vdd.n1403 16.0005
R2186 vdd.n1465 vdd.n1400 189.355
R2187 vdd.n1466 vdd.n1467 2.68753
R2188 vdd.n1467 vdd.n1468 0.15675
R2189 vdd.n1468 vdd.n1469 0.15675
R2190 vdd.n1469 vdd.n1470 0.15675
R2191 vdd.n1470 vdd.n1471 0.15675
R2192 vdd.n1471 vdd.n1472 0.15675
R2193 vdd.n1472 vdd.n1473 0.15675
R2194 vdd.n1473 vdd.n1474 0.15675
R2195 vdd.n1474 vdd.n1475 0.15675
R2196 vdd.n1475 vdd.n1476 0.15675
R2197 vdd.n1476 vdd.n1477 0.15675
R2198 vdd.n1477 vdd.n1478 0.15675
R2199 vdd.n1478 vdd.n1479 0.15675
R2200 vdd.n1479 vdd.n1480 0.15675
R2201 vdd.n1480 vdd.n1481 0.15675
R2202 vdd.n1481 vdd.n1482 0.15675
R2203 vdd.n1482 vdd.n1483 0.15675
R2204 vdd.n1483 vdd.n1484 0.15675
R2205 vdd.n1484 vdd.n1485 0.15675
R2206 vdd.n1485 vdd.n1465 2.68753
R2207 vdd.n1464 vdd.n1462 114.001
R2208 vdd.n1462 vdd.n1459 114.001
R2209 vdd.n1459 vdd.n1456 114.001
R2210 vdd.n1456 vdd.n1453 114.001
R2211 vdd.n1453 vdd.n1450 114.001
R2212 vdd.n1450 vdd.n1447 114.001
R2213 vdd.n1447 vdd.n1444 114.001
R2214 vdd.n1444 vdd.n1441 114.001
R2215 vdd.n1441 vdd.n1438 114.001
R2216 vdd.n1438 vdd.n1435 114.001
R2217 vdd.n1435 vdd.n1432 114.001
R2218 vdd.n1432 vdd.n1429 114.001
R2219 vdd.n1429 vdd.n1426 114.001
R2220 vdd.n1426 vdd.n1423 114.001
R2221 vdd.n1423 vdd.n1420 114.001
R2222 vdd.n1420 vdd.n1417 114.001
R2223 vdd.n1417 vdd.n1414 114.001
R2224 vdd.n1414 vdd.n1411 114.001
R2225 vdd.n1411 vdd.n1408 114.001
R2226 vdd.n1408 vdd.n1405 114.001
R2227 vdd.n1405 vdd.n1402 114.001
R2228 vdd.n1402 vdd.n1400 114.001
R2229 vdd.n1400 vdd.n1391 481.08
R2230 vdd.n1391 vdd.n1388 114.001
R2231 vdd.n1388 vdd.n1385 114.001
R2232 vdd.n1385 vdd.n1382 114.001
R2233 vdd.n1382 vdd.n1379 114.001
R2234 vdd.n1379 vdd.n1376 114.001
R2235 vdd.n1376 vdd.n1373 114.001
R2236 vdd.n1373 vdd.n1370 114.001
R2237 vdd.n1370 vdd.n1368 114.001
R2238 vdd.n1368 vdd.n1366 459.421
R2239 vdd.n1366 vdd.n1281 572.135
R2240 vdd.n1389 vdd.n1393 4.28224
R2241 vdd.n1386 vdd.n1394 9.3005
R2242 vdd.n1383 vdd.n1395 9.3005
R2243 vdd.n1380 vdd.n1396 9.3005
R2244 vdd.n1377 vdd.n1397 9.3005
R2245 vdd.n1374 vdd.n1398 9.3005
R2246 vdd.n1371 vdd.n1392 4.28224
R2247 vdd.n1391 vdd.n1393 189.355
R2248 vdd.n1389 vdd.n1386 16.0005
R2249 vdd.n1386 vdd.n1383 16.0005
R2250 vdd.n1383 vdd.n1380 16.0005
R2251 vdd.n1380 vdd.n1377 16.0005
R2252 vdd.n1377 vdd.n1374 16.0005
R2253 vdd.n1374 vdd.n1371 16.0005
R2254 vdd.n1392 vdd.n1368 189.355
R2255 vdd.n1393 vdd.n1394 2.68753
R2256 vdd.n1394 vdd.n1395 0.15675
R2257 vdd.n1395 vdd.n1396 0.15675
R2258 vdd.n1396 vdd.n1397 0.15675
R2259 vdd.n1397 vdd.n1398 0.15675
R2260 vdd.n1398 vdd.n1392 2.68753
R2261 vdd.n1198 vdd.n1197 22.62
R2262 vdd.n1197 vdd.t20 6.56613
R2263 vdd.n1197 vdd.t28 6.56613
R2264 vdd.n1196 vdd.n1195 9.6662
R2265 vdd.n1195 vdd.n951 8.11362
R2266 vdd.n951 vdd.n953 9.3005
R2267 vdd.n955 vdd.n954 9.3005
R2268 vdd.n957 vdd.n956 9.3005
R2269 vdd.n959 vdd.n958 9.3005
R2270 vdd.n961 vdd.n960 9.3005
R2271 vdd.n963 vdd.n962 9.3005
R2272 vdd.n965 vdd.n964 9.3005
R2273 vdd.n967 vdd.n966 9.3005
R2274 vdd.n969 vdd.n968 9.3005
R2275 vdd.n971 vdd.n970 9.3005
R2276 vdd.n973 vdd.n972 9.3005
R2277 vdd.n975 vdd.n974 9.3005
R2278 vdd.n977 vdd.n976 9.3005
R2279 vdd.n979 vdd.n978 9.3005
R2280 vdd.n981 vdd.n980 9.3005
R2281 vdd.n983 vdd.n982 9.3005
R2282 vdd.n985 vdd.n984 9.3005
R2283 vdd.n987 vdd.n986 9.3005
R2284 vdd.n989 vdd.n988 9.3005
R2285 vdd.n991 vdd.n990 9.3005
R2286 vdd.n993 vdd.n992 9.3005
R2287 vdd.n995 vdd.n994 9.3005
R2288 vdd.n997 vdd.n996 9.3005
R2289 vdd.n999 vdd.n998 9.3005
R2290 vdd.n1001 vdd.n1000 9.3005
R2291 vdd.n1003 vdd.n1002 9.3005
R2292 vdd.n1005 vdd.n1004 9.3005
R2293 vdd.n1007 vdd.n1006 9.3005
R2294 vdd.n1009 vdd.n1008 9.3005
R2295 vdd.n1011 vdd.n1010 9.3005
R2296 vdd.n1013 vdd.n1012 9.3005
R2297 vdd.n1015 vdd.n1014 9.3005
R2298 vdd.n1017 vdd.n1016 9.3005
R2299 vdd.n1019 vdd.n1018 9.3005
R2300 vdd.n952 vdd.n1020 4.28224
R2301 vdd.n951 vdd.n955 0.15675
R2302 vdd.n955 vdd.n957 0.15675
R2303 vdd.n957 vdd.n959 0.15675
R2304 vdd.n959 vdd.n961 0.15675
R2305 vdd.n961 vdd.n963 0.15675
R2306 vdd.n963 vdd.n965 0.15675
R2307 vdd.n965 vdd.n967 0.15675
R2308 vdd.n967 vdd.n969 0.15675
R2309 vdd.n969 vdd.n971 0.15675
R2310 vdd.n971 vdd.n973 0.15675
R2311 vdd.n973 vdd.n975 0.15675
R2312 vdd.n975 vdd.n977 0.15675
R2313 vdd.n977 vdd.n979 0.15675
R2314 vdd.n979 vdd.n981 0.15675
R2315 vdd.n981 vdd.n983 0.15675
R2316 vdd.n983 vdd.n985 0.15675
R2317 vdd.n985 vdd.n987 0.15675
R2318 vdd.n987 vdd.n989 0.15675
R2319 vdd.n989 vdd.n991 0.15675
R2320 vdd.n991 vdd.n993 0.15675
R2321 vdd.n993 vdd.n995 0.15675
R2322 vdd.n995 vdd.n997 0.15675
R2323 vdd.n997 vdd.n999 0.15675
R2324 vdd.n999 vdd.n1001 0.15675
R2325 vdd.n1001 vdd.n1003 0.15675
R2326 vdd.n1003 vdd.n1005 0.15675
R2327 vdd.n1005 vdd.n1007 0.15675
R2328 vdd.n1007 vdd.n1009 0.15675
R2329 vdd.n1009 vdd.n1011 0.15675
R2330 vdd.n1011 vdd.n1013 0.15675
R2331 vdd.n1013 vdd.n1015 0.15675
R2332 vdd.n1015 vdd.n1017 0.15675
R2333 vdd.n1017 vdd.n1019 0.15675
R2334 vdd.n1019 vdd.n952 2.68753
R2335 vdd.n952 vdd.n1021 189.355
R2336 vdd.n1023 vdd.n1022 185
R2337 vdd.n1020 vdd.n1023 185
R2338 vdd.n1025 vdd.n1024 185
R2339 vdd.n1018 vdd.n1025 185
R2340 vdd.n1027 vdd.n1026 185
R2341 vdd.n1016 vdd.n1027 185
R2342 vdd.n1029 vdd.n1028 185
R2343 vdd.n1014 vdd.n1029 185
R2344 vdd.n1031 vdd.n1030 185
R2345 vdd.n1012 vdd.n1031 185
R2346 vdd.n1033 vdd.n1032 185
R2347 vdd.n1010 vdd.n1033 185
R2348 vdd.n1035 vdd.n1034 185
R2349 vdd.n1008 vdd.n1035 185
R2350 vdd.n1037 vdd.n1036 185
R2351 vdd.n1006 vdd.n1037 185
R2352 vdd.n1039 vdd.n1038 185
R2353 vdd.n1004 vdd.n1039 185
R2354 vdd.n1041 vdd.n1040 185
R2355 vdd.n1002 vdd.n1041 185
R2356 vdd.n1043 vdd.n1042 185
R2357 vdd.n1000 vdd.n1043 185
R2358 vdd.n1045 vdd.n1044 185
R2359 vdd.n998 vdd.n1045 185
R2360 vdd.n1047 vdd.n1046 185
R2361 vdd.n996 vdd.n1047 185
R2362 vdd.n1049 vdd.n1048 185
R2363 vdd.n994 vdd.n1049 185
R2364 vdd.n1051 vdd.n1050 185
R2365 vdd.n992 vdd.n1051 185
R2366 vdd.n1053 vdd.n1052 185
R2367 vdd.n990 vdd.n1053 185
R2368 vdd.n1055 vdd.n1054 185
R2369 vdd.n988 vdd.n1055 185
R2370 vdd.n1057 vdd.n1056 185
R2371 vdd.n986 vdd.n1057 185
R2372 vdd.n1059 vdd.n1058 185
R2373 vdd.n984 vdd.n1059 185
R2374 vdd.n1061 vdd.n1060 185
R2375 vdd.n982 vdd.n1061 185
R2376 vdd.n1063 vdd.n1062 185
R2377 vdd.n980 vdd.n1063 185
R2378 vdd.n1065 vdd.n1064 185
R2379 vdd.n978 vdd.n1065 185
R2380 vdd.n1067 vdd.n1066 185
R2381 vdd.n976 vdd.n1067 185
R2382 vdd.n1069 vdd.n1068 185
R2383 vdd.n974 vdd.n1069 185
R2384 vdd.n1071 vdd.n1070 185
R2385 vdd.n972 vdd.n1071 185
R2386 vdd.n1073 vdd.n1072 185
R2387 vdd.n970 vdd.n1073 185
R2388 vdd.n1075 vdd.n1074 185
R2389 vdd.n968 vdd.n1075 185
R2390 vdd.n1077 vdd.n1076 185
R2391 vdd.n966 vdd.n1077 185
R2392 vdd.n1079 vdd.n1078 185
R2393 vdd.n964 vdd.n1079 185
R2394 vdd.n1081 vdd.n1080 185
R2395 vdd.n962 vdd.n1081 185
R2396 vdd.n1083 vdd.n1082 185
R2397 vdd.n960 vdd.n1083 185
R2398 vdd.n1085 vdd.n1084 185
R2399 vdd.n958 vdd.n1085 185
R2400 vdd.n1087 vdd.n1086 185
R2401 vdd.n956 vdd.n1087 185
R2402 vdd.n1089 vdd.n1088 185
R2403 vdd.n954 vdd.n1089 185
R2404 vdd.n953 vdd.n1194 185
R2405 vdd.n953 vdd.n954 16.0005
R2406 vdd.n954 vdd.n956 16.0005
R2407 vdd.n956 vdd.n958 16.0005
R2408 vdd.n958 vdd.n960 16.0005
R2409 vdd.n960 vdd.n962 16.0005
R2410 vdd.n962 vdd.n964 16.0005
R2411 vdd.n964 vdd.n966 16.0005
R2412 vdd.n966 vdd.n968 16.0005
R2413 vdd.n968 vdd.n970 16.0005
R2414 vdd.n970 vdd.n972 16.0005
R2415 vdd.n972 vdd.n974 16.0005
R2416 vdd.n974 vdd.n976 16.0005
R2417 vdd.n976 vdd.n978 16.0005
R2418 vdd.n978 vdd.n980 16.0005
R2419 vdd.n980 vdd.n982 16.0005
R2420 vdd.n982 vdd.n984 16.0005
R2421 vdd.n984 vdd.n986 16.0005
R2422 vdd.n986 vdd.n988 16.0005
R2423 vdd.n988 vdd.n990 16.0005
R2424 vdd.n990 vdd.n992 16.0005
R2425 vdd.n992 vdd.n994 16.0005
R2426 vdd.n994 vdd.n996 16.0005
R2427 vdd.n996 vdd.n998 16.0005
R2428 vdd.n998 vdd.n1000 16.0005
R2429 vdd.n1000 vdd.n1002 16.0005
R2430 vdd.n1002 vdd.n1004 16.0005
R2431 vdd.n1004 vdd.n1006 16.0005
R2432 vdd.n1006 vdd.n1008 16.0005
R2433 vdd.n1008 vdd.n1010 16.0005
R2434 vdd.n1010 vdd.n1012 16.0005
R2435 vdd.n1012 vdd.n1014 16.0005
R2436 vdd.n1014 vdd.n1016 16.0005
R2437 vdd.n1016 vdd.n1018 16.0005
R2438 vdd.n1018 vdd.n1020 16.0005
R2439 vdd.n1194 vdd.n1089 114.001
R2440 vdd.n1089 vdd.n1087 114.001
R2441 vdd.n1087 vdd.n1085 114.001
R2442 vdd.n1085 vdd.n1083 114.001
R2443 vdd.n1083 vdd.n1081 114.001
R2444 vdd.n1081 vdd.n1079 114.001
R2445 vdd.n1079 vdd.n1077 114.001
R2446 vdd.n1077 vdd.n1075 114.001
R2447 vdd.n1075 vdd.n1073 114.001
R2448 vdd.n1073 vdd.n1071 114.001
R2449 vdd.n1071 vdd.n1069 114.001
R2450 vdd.n1069 vdd.n1067 114.001
R2451 vdd.n1067 vdd.n1065 114.001
R2452 vdd.n1065 vdd.n1063 114.001
R2453 vdd.n1063 vdd.n1061 114.001
R2454 vdd.n1061 vdd.n1059 114.001
R2455 vdd.n1059 vdd.n1057 114.001
R2456 vdd.n1057 vdd.n1055 114.001
R2457 vdd.n1055 vdd.n1053 114.001
R2458 vdd.n1053 vdd.n1051 114.001
R2459 vdd.n1051 vdd.n1049 114.001
R2460 vdd.n1049 vdd.n1047 114.001
R2461 vdd.n1047 vdd.n1045 114.001
R2462 vdd.n1045 vdd.n1043 114.001
R2463 vdd.n1043 vdd.n1041 114.001
R2464 vdd.n1041 vdd.n1039 114.001
R2465 vdd.n1039 vdd.n1037 114.001
R2466 vdd.n1037 vdd.n1035 114.001
R2467 vdd.n1035 vdd.n1033 114.001
R2468 vdd.n1033 vdd.n1031 114.001
R2469 vdd.n1031 vdd.n1029 114.001
R2470 vdd.n1029 vdd.n1027 114.001
R2471 vdd.n1027 vdd.n1025 114.001
R2472 vdd.n1025 vdd.n1023 114.001
R2473 vdd.n1023 vdd.n1021 114.001
R2474 vdd.n1090 vdd.n1091 185
R2475 vdd.n1092 vdd.n1093 185
R2476 vdd.n1093 vdd.n1094 185
R2477 vdd.n1095 vdd.n1096 185
R2478 vdd.n1096 vdd.n1097 185
R2479 vdd.n1098 vdd.n1099 185
R2480 vdd.n1099 vdd.n1100 185
R2481 vdd.n1101 vdd.n1102 185
R2482 vdd.n1106 vdd.n1107 185
R2483 vdd.n1108 vdd.n1109 185
R2484 vdd.n1109 vdd.n1110 185
R2485 vdd.n1111 vdd.n1112 185
R2486 vdd.n1112 vdd.n1113 185
R2487 vdd.n1114 vdd.n1115 185
R2488 vdd.n1115 vdd.n1116 185
R2489 vdd.n1117 vdd.n1118 185
R2490 vdd.n1118 vdd.n1119 185
R2491 vdd.n1120 vdd.n1121 185
R2492 vdd.n1121 vdd.n1122 185
R2493 vdd.n1123 vdd.n1124 185
R2494 vdd.n1124 vdd.n1125 185
R2495 vdd.n1126 vdd.n1127 185
R2496 vdd.n1127 vdd.n1128 185
R2497 vdd.n1129 vdd.n1130 185
R2498 vdd.n1138 vdd.n1139 185
R2499 vdd.n1140 vdd.n1141 185
R2500 vdd.n1141 vdd.n1142 185
R2501 vdd.n1143 vdd.n1144 185
R2502 vdd.n1144 vdd.n1145 185
R2503 vdd.n1146 vdd.n1147 185
R2504 vdd.n1147 vdd.n1148 185
R2505 vdd.n1149 vdd.n1150 185
R2506 vdd.n1150 vdd.n1151 185
R2507 vdd.n1152 vdd.n1153 185
R2508 vdd.n1153 vdd.n1154 185
R2509 vdd.n1155 vdd.n1156 185
R2510 vdd.n1156 vdd.n1157 185
R2511 vdd.n1158 vdd.n1159 185
R2512 vdd.n1159 vdd.n1160 185
R2513 vdd.n1161 vdd.n1162 185
R2514 vdd.n1162 vdd.n1163 185
R2515 vdd.n1164 vdd.n1165 185
R2516 vdd.n1165 vdd.n1166 185
R2517 vdd.n1167 vdd.n1168 185
R2518 vdd.n1168 vdd.n1169 185
R2519 vdd.n1170 vdd.n1171 185
R2520 vdd.n1171 vdd.n1172 185
R2521 vdd.n1173 vdd.n1174 185
R2522 vdd.n1174 vdd.n1175 185
R2523 vdd.n1176 vdd.n1177 185
R2524 vdd.n1177 vdd.n1178 185
R2525 vdd.n1179 vdd.n1180 185
R2526 vdd.n1194 vdd.n1179 187.927
R2527 vdd.n1179 vdd.n1088 16.5816
R2528 vdd.n1088 vdd.n1176 2.92658
R2529 vdd.n1176 vdd.n1086 16.5816
R2530 vdd.n1086 vdd.n1173 2.92658
R2531 vdd.n1173 vdd.n1084 16.5816
R2532 vdd.n1084 vdd.n1170 2.92658
R2533 vdd.n1170 vdd.n1082 16.5816
R2534 vdd.n1082 vdd.n1167 2.92658
R2535 vdd.n1167 vdd.n1080 16.5816
R2536 vdd.n1080 vdd.t23 1.95122
R2537 vdd.t23 vdd.n1164 0.975859
R2538 vdd.n1164 vdd.n1078 16.5816
R2539 vdd.n1078 vdd.n1161 2.92658
R2540 vdd.n1161 vdd.n1076 16.5816
R2541 vdd.n1076 vdd.n1158 2.92658
R2542 vdd.n1158 vdd.n1074 16.5816
R2543 vdd.n1074 vdd.n1155 2.92658
R2544 vdd.n1155 vdd.n1072 16.5816
R2545 vdd.n1072 vdd.n1152 2.92658
R2546 vdd.n1152 vdd.n1070 16.5816
R2547 vdd.n1070 vdd.n1149 2.92658
R2548 vdd.n1149 vdd.n1068 16.5816
R2549 vdd.n1068 vdd.n1146 2.92658
R2550 vdd.n1146 vdd.n1066 16.5816
R2551 vdd.n1066 vdd.n1143 2.92658
R2552 vdd.n1143 vdd.n1064 16.5816
R2553 vdd.n1064 vdd.n1140 2.92658
R2554 vdd.n1140 vdd.t0 2.92658
R2555 vdd.t0 vdd.n1062 13.6555
R2556 vdd.n1062 vdd.n1138 2.92658
R2557 vdd.n1138 vdd.n1060 16.5816
R2558 vdd.n1060 vdd.n1058 19.5077
R2559 vdd.n1058 vdd.n1056 19.5077
R2560 vdd.n1056 vdd.n1054 19.5077
R2561 vdd.n1054 vdd.n1129 11.7048
R2562 vdd.n1052 vdd.n1129 7.80337
R2563 vdd.n1052 vdd.t8 9.75409
R2564 vdd.t8 vdd.n1126 1.95122
R2565 vdd.n1050 vdd.n1126 7.80337
R2566 vdd.n1050 vdd.n1123 11.7048
R2567 vdd.n1048 vdd.n1123 7.80337
R2568 vdd.n1048 vdd.n1120 11.7048
R2569 vdd.n1046 vdd.n1120 7.80337
R2570 vdd.n1046 vdd.n1117 11.7048
R2571 vdd.n1044 vdd.n1117 7.80337
R2572 vdd.n1044 vdd.n1114 11.7048
R2573 vdd.n1042 vdd.n1114 7.80337
R2574 vdd.n1042 vdd.n1111 11.7048
R2575 vdd.n1040 vdd.n1111 7.80337
R2576 vdd.n1040 vdd.n1108 11.7048
R2577 vdd.t35 vdd.n1108 1.95122
R2578 vdd.n1038 vdd.t35 5.85266
R2579 vdd.n1038 vdd.n1106 11.7048
R2580 vdd.n1036 vdd.n1106 7.80337
R2581 vdd.n1036 vdd.n1034 19.5077
R2582 vdd.n1034 vdd.n1032 19.5077
R2583 vdd.n1032 vdd.n1030 19.5077
R2584 vdd.n1030 vdd.n1101 18.5323
R2585 vdd.n1028 vdd.n1101 0.975859
R2586 vdd.n1028 vdd.t36 17.557
R2587 vdd.n1098 vdd.t36 0.975859
R2588 vdd.n1026 vdd.n1098 0.975859
R2589 vdd.n1026 vdd.n1095 18.5323
R2590 vdd.n1024 vdd.n1095 0.975859
R2591 vdd.n1024 vdd.n1092 18.5323
R2592 vdd.n1022 vdd.n1092 0.975859
R2593 vdd.n1022 vdd.n1090 18.5323
R2594 vdd.n1021 vdd.n1090 185.976
R2595 vdd.n1178 vdd.n1182 4.28224
R2596 vdd.n1175 vdd.n1183 9.3005
R2597 vdd.n1172 vdd.n1184 9.3005
R2598 vdd.n1169 vdd.n1185 9.3005
R2599 vdd.n1166 vdd.n1186 9.3005
R2600 vdd.n1163 vdd.n1187 9.3005
R2601 vdd.n1160 vdd.n1188 9.3005
R2602 vdd.n1157 vdd.n1189 9.3005
R2603 vdd.n1154 vdd.n1190 9.3005
R2604 vdd.n1151 vdd.n1191 9.3005
R2605 vdd.n1148 vdd.n1192 9.3005
R2606 vdd.n1145 vdd.n1193 9.3005
R2607 vdd.n1142 vdd.n1181 4.28224
R2608 vdd.n1180 vdd.n1182 189.355
R2609 vdd.n1178 vdd.n1175 16.0005
R2610 vdd.n1175 vdd.n1172 16.0005
R2611 vdd.n1172 vdd.n1169 16.0005
R2612 vdd.n1169 vdd.n1166 16.0005
R2613 vdd.n1166 vdd.n1163 16.0005
R2614 vdd.n1163 vdd.n1160 16.0005
R2615 vdd.n1160 vdd.n1157 16.0005
R2616 vdd.n1157 vdd.n1154 16.0005
R2617 vdd.n1154 vdd.n1151 16.0005
R2618 vdd.n1151 vdd.n1148 16.0005
R2619 vdd.n1148 vdd.n1145 16.0005
R2620 vdd.n1145 vdd.n1142 16.0005
R2621 vdd.n1181 vdd.n1139 189.355
R2622 vdd.n1182 vdd.n1183 2.68753
R2623 vdd.n1183 vdd.n1184 0.15675
R2624 vdd.n1184 vdd.n1185 0.15675
R2625 vdd.n1185 vdd.n1186 0.15675
R2626 vdd.n1186 vdd.n1187 0.15675
R2627 vdd.n1187 vdd.n1188 0.15675
R2628 vdd.n1188 vdd.n1189 0.15675
R2629 vdd.n1189 vdd.n1190 0.15675
R2630 vdd.n1190 vdd.n1191 0.15675
R2631 vdd.n1191 vdd.n1192 0.15675
R2632 vdd.n1192 vdd.n1193 0.15675
R2633 vdd.n1193 vdd.n1181 2.68753
R2634 vdd.n1180 vdd.n1177 114.001
R2635 vdd.n1177 vdd.n1174 114.001
R2636 vdd.n1174 vdd.n1171 114.001
R2637 vdd.n1171 vdd.n1168 114.001
R2638 vdd.n1168 vdd.n1165 114.001
R2639 vdd.n1165 vdd.n1162 114.001
R2640 vdd.n1162 vdd.n1159 114.001
R2641 vdd.n1159 vdd.n1156 114.001
R2642 vdd.n1156 vdd.n1153 114.001
R2643 vdd.n1153 vdd.n1150 114.001
R2644 vdd.n1150 vdd.n1147 114.001
R2645 vdd.n1147 vdd.n1144 114.001
R2646 vdd.n1144 vdd.n1141 114.001
R2647 vdd.n1141 vdd.n1139 114.001
R2648 vdd.n1139 vdd.n1130 507.3
R2649 vdd.n1130 vdd.n1127 114.001
R2650 vdd.n1127 vdd.n1124 114.001
R2651 vdd.n1124 vdd.n1121 114.001
R2652 vdd.n1121 vdd.n1118 114.001
R2653 vdd.n1118 vdd.n1115 114.001
R2654 vdd.n1115 vdd.n1112 114.001
R2655 vdd.n1112 vdd.n1109 114.001
R2656 vdd.n1109 vdd.n1107 114.001
R2657 vdd.n1107 vdd.n1102 495.901
R2658 vdd.n1102 vdd.n1099 114.001
R2659 vdd.n1099 vdd.n1096 114.001
R2660 vdd.n1096 vdd.n1093 114.001
R2661 vdd.n1093 vdd.n1091 114.001
R2662 vdd.n1128 vdd.n1132 4.28224
R2663 vdd.n1125 vdd.n1133 9.3005
R2664 vdd.n1122 vdd.n1134 9.3005
R2665 vdd.n1119 vdd.n1135 9.3005
R2666 vdd.n1116 vdd.n1136 9.3005
R2667 vdd.n1113 vdd.n1137 9.3005
R2668 vdd.n1110 vdd.n1131 4.28224
R2669 vdd.n1130 vdd.n1132 189.355
R2670 vdd.n1128 vdd.n1125 16.0005
R2671 vdd.n1125 vdd.n1122 16.0005
R2672 vdd.n1122 vdd.n1119 16.0005
R2673 vdd.n1119 vdd.n1116 16.0005
R2674 vdd.n1116 vdd.n1113 16.0005
R2675 vdd.n1113 vdd.n1110 16.0005
R2676 vdd.n1131 vdd.n1107 189.355
R2677 vdd.n1132 vdd.n1133 2.68753
R2678 vdd.n1133 vdd.n1134 0.15675
R2679 vdd.n1134 vdd.n1135 0.15675
R2680 vdd.n1135 vdd.n1136 0.15675
R2681 vdd.n1136 vdd.n1137 0.15675
R2682 vdd.n1137 vdd.n1131 2.68753
R2683 vdd.n1100 vdd.n1104 4.28224
R2684 vdd.n1097 vdd.n1105 9.3005
R2685 vdd.n1094 vdd.n1103 4.28224
R2686 vdd.n1102 vdd.n1104 189.355
R2687 vdd.n1100 vdd.n1097 16.0005
R2688 vdd.n1097 vdd.n1094 16.0005
R2689 vdd.n1103 vdd.n1091 189.355
R2690 vdd.n1104 vdd.n1105 2.68753
R2691 vdd.n1103 vdd.n1105 2.68753
R2692 vdd.n951 vdd.t24 29.1857
R2693 vdd.n1195 vdd.n707 10.2192
R2694 vdd.n707 vdd.n709 9.3005
R2695 vdd.n711 vdd.n710 9.3005
R2696 vdd.n713 vdd.n712 9.3005
R2697 vdd.n715 vdd.n714 9.3005
R2698 vdd.n717 vdd.n716 9.3005
R2699 vdd.n719 vdd.n718 9.3005
R2700 vdd.n721 vdd.n720 9.3005
R2701 vdd.n723 vdd.n722 9.3005
R2702 vdd.n725 vdd.n724 9.3005
R2703 vdd.n727 vdd.n726 9.3005
R2704 vdd.n729 vdd.n728 9.3005
R2705 vdd.n731 vdd.n730 9.3005
R2706 vdd.n733 vdd.n732 9.3005
R2707 vdd.n735 vdd.n734 9.3005
R2708 vdd.n737 vdd.n736 9.3005
R2709 vdd.n739 vdd.n738 9.3005
R2710 vdd.n741 vdd.n740 9.3005
R2711 vdd.n743 vdd.n742 9.3005
R2712 vdd.n745 vdd.n744 9.3005
R2713 vdd.n747 vdd.n746 9.3005
R2714 vdd.n749 vdd.n748 9.3005
R2715 vdd.n751 vdd.n750 9.3005
R2716 vdd.n753 vdd.n752 9.3005
R2717 vdd.n755 vdd.n754 9.3005
R2718 vdd.n757 vdd.n756 9.3005
R2719 vdd.n759 vdd.n758 9.3005
R2720 vdd.n761 vdd.n760 9.3005
R2721 vdd.n763 vdd.n762 9.3005
R2722 vdd.n765 vdd.n764 9.3005
R2723 vdd.n767 vdd.n766 9.3005
R2724 vdd.n769 vdd.n768 9.3005
R2725 vdd.n771 vdd.n770 9.3005
R2726 vdd.n773 vdd.n772 9.3005
R2727 vdd.n775 vdd.n774 9.3005
R2728 vdd.n708 vdd.n776 4.28224
R2729 vdd.n707 vdd.n711 0.15675
R2730 vdd.n711 vdd.n713 0.15675
R2731 vdd.n713 vdd.n715 0.15675
R2732 vdd.n715 vdd.n717 0.15675
R2733 vdd.n717 vdd.n719 0.15675
R2734 vdd.n719 vdd.n721 0.15675
R2735 vdd.n721 vdd.n723 0.15675
R2736 vdd.n723 vdd.n725 0.15675
R2737 vdd.n725 vdd.n727 0.15675
R2738 vdd.n727 vdd.n729 0.15675
R2739 vdd.n729 vdd.n731 0.15675
R2740 vdd.n731 vdd.n733 0.15675
R2741 vdd.n733 vdd.n735 0.15675
R2742 vdd.n735 vdd.n737 0.15675
R2743 vdd.n737 vdd.n739 0.15675
R2744 vdd.n739 vdd.n741 0.15675
R2745 vdd.n741 vdd.n743 0.15675
R2746 vdd.n743 vdd.n745 0.15675
R2747 vdd.n745 vdd.n747 0.15675
R2748 vdd.n747 vdd.n749 0.15675
R2749 vdd.n749 vdd.n751 0.15675
R2750 vdd.n751 vdd.n753 0.15675
R2751 vdd.n753 vdd.n755 0.15675
R2752 vdd.n755 vdd.n757 0.15675
R2753 vdd.n757 vdd.n759 0.15675
R2754 vdd.n759 vdd.n761 0.15675
R2755 vdd.n761 vdd.n763 0.15675
R2756 vdd.n763 vdd.n765 0.15675
R2757 vdd.n765 vdd.n767 0.15675
R2758 vdd.n767 vdd.n769 0.15675
R2759 vdd.n769 vdd.n771 0.15675
R2760 vdd.n771 vdd.n773 0.15675
R2761 vdd.n773 vdd.n775 0.15675
R2762 vdd.n775 vdd.n708 2.68753
R2763 vdd.n708 vdd.n777 189.355
R2764 vdd.n779 vdd.n778 185
R2765 vdd.n776 vdd.n779 185
R2766 vdd.n781 vdd.n780 185
R2767 vdd.n774 vdd.n781 185
R2768 vdd.n783 vdd.n782 185
R2769 vdd.n772 vdd.n783 185
R2770 vdd.n785 vdd.n784 185
R2771 vdd.n770 vdd.n785 185
R2772 vdd.n787 vdd.n786 185
R2773 vdd.n768 vdd.n787 185
R2774 vdd.n789 vdd.n788 185
R2775 vdd.n766 vdd.n789 185
R2776 vdd.n791 vdd.n790 185
R2777 vdd.n764 vdd.n791 185
R2778 vdd.n793 vdd.n792 185
R2779 vdd.n762 vdd.n793 185
R2780 vdd.n795 vdd.n794 185
R2781 vdd.n760 vdd.n795 185
R2782 vdd.n797 vdd.n796 185
R2783 vdd.n758 vdd.n797 185
R2784 vdd.n799 vdd.n798 185
R2785 vdd.n756 vdd.n799 185
R2786 vdd.n801 vdd.n800 185
R2787 vdd.n754 vdd.n801 185
R2788 vdd.n803 vdd.n802 185
R2789 vdd.n752 vdd.n803 185
R2790 vdd.n805 vdd.n804 185
R2791 vdd.n750 vdd.n805 185
R2792 vdd.n807 vdd.n806 185
R2793 vdd.n748 vdd.n807 185
R2794 vdd.n809 vdd.n808 185
R2795 vdd.n746 vdd.n809 185
R2796 vdd.n811 vdd.n810 185
R2797 vdd.n744 vdd.n811 185
R2798 vdd.n813 vdd.n812 185
R2799 vdd.n742 vdd.n813 185
R2800 vdd.n815 vdd.n814 185
R2801 vdd.n740 vdd.n815 185
R2802 vdd.n817 vdd.n816 185
R2803 vdd.n738 vdd.n817 185
R2804 vdd.n819 vdd.n818 185
R2805 vdd.n736 vdd.n819 185
R2806 vdd.n821 vdd.n820 185
R2807 vdd.n734 vdd.n821 185
R2808 vdd.n823 vdd.n822 185
R2809 vdd.n732 vdd.n823 185
R2810 vdd.n825 vdd.n824 185
R2811 vdd.n730 vdd.n825 185
R2812 vdd.n827 vdd.n826 185
R2813 vdd.n728 vdd.n827 185
R2814 vdd.n829 vdd.n828 185
R2815 vdd.n726 vdd.n829 185
R2816 vdd.n831 vdd.n830 185
R2817 vdd.n724 vdd.n831 185
R2818 vdd.n833 vdd.n832 185
R2819 vdd.n722 vdd.n833 185
R2820 vdd.n835 vdd.n834 185
R2821 vdd.n720 vdd.n835 185
R2822 vdd.n837 vdd.n836 185
R2823 vdd.n718 vdd.n837 185
R2824 vdd.n839 vdd.n838 185
R2825 vdd.n716 vdd.n839 185
R2826 vdd.n841 vdd.n840 185
R2827 vdd.n714 vdd.n841 185
R2828 vdd.n843 vdd.n842 185
R2829 vdd.n712 vdd.n843 185
R2830 vdd.n845 vdd.n844 185
R2831 vdd.n710 vdd.n845 185
R2832 vdd.n709 vdd.n950 185
R2833 vdd.n709 vdd.n710 16.0005
R2834 vdd.n710 vdd.n712 16.0005
R2835 vdd.n712 vdd.n714 16.0005
R2836 vdd.n714 vdd.n716 16.0005
R2837 vdd.n716 vdd.n718 16.0005
R2838 vdd.n718 vdd.n720 16.0005
R2839 vdd.n720 vdd.n722 16.0005
R2840 vdd.n722 vdd.n724 16.0005
R2841 vdd.n724 vdd.n726 16.0005
R2842 vdd.n726 vdd.n728 16.0005
R2843 vdd.n728 vdd.n730 16.0005
R2844 vdd.n730 vdd.n732 16.0005
R2845 vdd.n732 vdd.n734 16.0005
R2846 vdd.n734 vdd.n736 16.0005
R2847 vdd.n736 vdd.n738 16.0005
R2848 vdd.n738 vdd.n740 16.0005
R2849 vdd.n740 vdd.n742 16.0005
R2850 vdd.n742 vdd.n744 16.0005
R2851 vdd.n744 vdd.n746 16.0005
R2852 vdd.n746 vdd.n748 16.0005
R2853 vdd.n748 vdd.n750 16.0005
R2854 vdd.n750 vdd.n752 16.0005
R2855 vdd.n752 vdd.n754 16.0005
R2856 vdd.n754 vdd.n756 16.0005
R2857 vdd.n756 vdd.n758 16.0005
R2858 vdd.n758 vdd.n760 16.0005
R2859 vdd.n760 vdd.n762 16.0005
R2860 vdd.n762 vdd.n764 16.0005
R2861 vdd.n764 vdd.n766 16.0005
R2862 vdd.n766 vdd.n768 16.0005
R2863 vdd.n768 vdd.n770 16.0005
R2864 vdd.n770 vdd.n772 16.0005
R2865 vdd.n772 vdd.n774 16.0005
R2866 vdd.n774 vdd.n776 16.0005
R2867 vdd.n950 vdd.n845 114.001
R2868 vdd.n845 vdd.n843 114.001
R2869 vdd.n843 vdd.n841 114.001
R2870 vdd.n841 vdd.n839 114.001
R2871 vdd.n839 vdd.n837 114.001
R2872 vdd.n837 vdd.n835 114.001
R2873 vdd.n835 vdd.n833 114.001
R2874 vdd.n833 vdd.n831 114.001
R2875 vdd.n831 vdd.n829 114.001
R2876 vdd.n829 vdd.n827 114.001
R2877 vdd.n827 vdd.n825 114.001
R2878 vdd.n825 vdd.n823 114.001
R2879 vdd.n823 vdd.n821 114.001
R2880 vdd.n821 vdd.n819 114.001
R2881 vdd.n819 vdd.n817 114.001
R2882 vdd.n817 vdd.n815 114.001
R2883 vdd.n815 vdd.n813 114.001
R2884 vdd.n813 vdd.n811 114.001
R2885 vdd.n811 vdd.n809 114.001
R2886 vdd.n809 vdd.n807 114.001
R2887 vdd.n807 vdd.n805 114.001
R2888 vdd.n805 vdd.n803 114.001
R2889 vdd.n803 vdd.n801 114.001
R2890 vdd.n801 vdd.n799 114.001
R2891 vdd.n799 vdd.n797 114.001
R2892 vdd.n797 vdd.n795 114.001
R2893 vdd.n795 vdd.n793 114.001
R2894 vdd.n793 vdd.n791 114.001
R2895 vdd.n791 vdd.n789 114.001
R2896 vdd.n789 vdd.n787 114.001
R2897 vdd.n787 vdd.n785 114.001
R2898 vdd.n785 vdd.n783 114.001
R2899 vdd.n783 vdd.n781 114.001
R2900 vdd.n781 vdd.n779 114.001
R2901 vdd.n779 vdd.n777 114.001
R2902 vdd.n846 vdd.n847 185
R2903 vdd.n848 vdd.n849 185
R2904 vdd.n849 vdd.n850 185
R2905 vdd.n851 vdd.n852 185
R2906 vdd.n852 vdd.n853 185
R2907 vdd.n854 vdd.n855 185
R2908 vdd.n855 vdd.n856 185
R2909 vdd.n857 vdd.n858 185
R2910 vdd.n862 vdd.n863 185
R2911 vdd.n864 vdd.n865 185
R2912 vdd.n865 vdd.n866 185
R2913 vdd.n867 vdd.n868 185
R2914 vdd.n868 vdd.n869 185
R2915 vdd.n870 vdd.n871 185
R2916 vdd.n871 vdd.n872 185
R2917 vdd.n873 vdd.n874 185
R2918 vdd.n874 vdd.n875 185
R2919 vdd.n876 vdd.n877 185
R2920 vdd.n877 vdd.n878 185
R2921 vdd.n879 vdd.n880 185
R2922 vdd.n880 vdd.n881 185
R2923 vdd.n882 vdd.n883 185
R2924 vdd.n883 vdd.n884 185
R2925 vdd.n885 vdd.n886 185
R2926 vdd.n894 vdd.n895 185
R2927 vdd.n896 vdd.n897 185
R2928 vdd.n897 vdd.n898 185
R2929 vdd.n899 vdd.n900 185
R2930 vdd.n900 vdd.n901 185
R2931 vdd.n902 vdd.n903 185
R2932 vdd.n903 vdd.n904 185
R2933 vdd.n905 vdd.n906 185
R2934 vdd.n906 vdd.n907 185
R2935 vdd.n908 vdd.n909 185
R2936 vdd.n909 vdd.n910 185
R2937 vdd.n911 vdd.n912 185
R2938 vdd.n912 vdd.n913 185
R2939 vdd.n914 vdd.n915 185
R2940 vdd.n915 vdd.n916 185
R2941 vdd.n917 vdd.n918 185
R2942 vdd.n918 vdd.n919 185
R2943 vdd.n920 vdd.n921 185
R2944 vdd.n921 vdd.n922 185
R2945 vdd.n923 vdd.n924 185
R2946 vdd.n924 vdd.n925 185
R2947 vdd.n926 vdd.n927 185
R2948 vdd.n927 vdd.n928 185
R2949 vdd.n929 vdd.n930 185
R2950 vdd.n930 vdd.n931 185
R2951 vdd.n932 vdd.n933 185
R2952 vdd.n933 vdd.n934 185
R2953 vdd.n935 vdd.n936 185
R2954 vdd.n950 vdd.n935 187.927
R2955 vdd.n935 vdd.n844 16.5816
R2956 vdd.n844 vdd.n932 2.92658
R2957 vdd.n932 vdd.n842 16.5816
R2958 vdd.n842 vdd.n929 2.92658
R2959 vdd.n929 vdd.n840 16.5816
R2960 vdd.n840 vdd.n926 2.92658
R2961 vdd.n926 vdd.n838 16.5816
R2962 vdd.n838 vdd.n923 2.92658
R2963 vdd.n923 vdd.n836 16.5816
R2964 vdd.n836 vdd.t21 1.95122
R2965 vdd.t21 vdd.n920 0.975859
R2966 vdd.n920 vdd.n834 16.5816
R2967 vdd.n834 vdd.n917 2.92658
R2968 vdd.n917 vdd.n832 16.5816
R2969 vdd.n832 vdd.n914 2.92658
R2970 vdd.n914 vdd.n830 16.5816
R2971 vdd.n830 vdd.n911 2.92658
R2972 vdd.n911 vdd.n828 16.5816
R2973 vdd.n828 vdd.n908 2.92658
R2974 vdd.n908 vdd.n826 16.5816
R2975 vdd.n826 vdd.n905 2.92658
R2976 vdd.n905 vdd.n824 16.5816
R2977 vdd.n824 vdd.n902 2.92658
R2978 vdd.n902 vdd.n822 16.5816
R2979 vdd.n822 vdd.n899 2.92658
R2980 vdd.n899 vdd.n820 16.5816
R2981 vdd.n820 vdd.n896 2.92658
R2982 vdd.n896 vdd.t1 2.92658
R2983 vdd.t1 vdd.n818 13.6555
R2984 vdd.n818 vdd.n894 2.92658
R2985 vdd.n894 vdd.n816 16.5816
R2986 vdd.n816 vdd.n814 19.5077
R2987 vdd.n814 vdd.n812 19.5077
R2988 vdd.n812 vdd.n810 19.5077
R2989 vdd.n810 vdd.n885 11.7048
R2990 vdd.n808 vdd.n885 7.80337
R2991 vdd.n808 vdd.t9 9.75409
R2992 vdd.t9 vdd.n882 1.95122
R2993 vdd.n806 vdd.n882 7.80337
R2994 vdd.n806 vdd.n879 11.7048
R2995 vdd.n804 vdd.n879 7.80337
R2996 vdd.n804 vdd.n876 11.7048
R2997 vdd.n802 vdd.n876 7.80337
R2998 vdd.n802 vdd.n873 11.7048
R2999 vdd.n800 vdd.n873 7.80337
R3000 vdd.n800 vdd.n870 11.7048
R3001 vdd.n798 vdd.n870 7.80337
R3002 vdd.n798 vdd.n867 11.7048
R3003 vdd.n796 vdd.n867 7.80337
R3004 vdd.n796 vdd.n864 11.7048
R3005 vdd.t33 vdd.n864 1.95122
R3006 vdd.n794 vdd.t33 5.85266
R3007 vdd.n794 vdd.n862 11.7048
R3008 vdd.n792 vdd.n862 7.80337
R3009 vdd.n792 vdd.n790 19.5077
R3010 vdd.n790 vdd.n788 19.5077
R3011 vdd.n788 vdd.n786 19.5077
R3012 vdd.n786 vdd.n857 18.5323
R3013 vdd.n784 vdd.n857 0.975859
R3014 vdd.n784 vdd.t34 17.557
R3015 vdd.n854 vdd.t34 0.975859
R3016 vdd.n782 vdd.n854 0.975859
R3017 vdd.n782 vdd.n851 18.5323
R3018 vdd.n780 vdd.n851 0.975859
R3019 vdd.n780 vdd.n848 18.5323
R3020 vdd.n778 vdd.n848 0.975859
R3021 vdd.n778 vdd.n846 18.5323
R3022 vdd.n777 vdd.n846 185.976
R3023 vdd.n934 vdd.n938 4.28224
R3024 vdd.n931 vdd.n939 9.3005
R3025 vdd.n928 vdd.n940 9.3005
R3026 vdd.n925 vdd.n941 9.3005
R3027 vdd.n922 vdd.n942 9.3005
R3028 vdd.n919 vdd.n943 9.3005
R3029 vdd.n916 vdd.n944 9.3005
R3030 vdd.n913 vdd.n945 9.3005
R3031 vdd.n910 vdd.n946 9.3005
R3032 vdd.n907 vdd.n947 9.3005
R3033 vdd.n904 vdd.n948 9.3005
R3034 vdd.n901 vdd.n949 9.3005
R3035 vdd.n898 vdd.n937 4.28224
R3036 vdd.n936 vdd.n938 189.355
R3037 vdd.n934 vdd.n931 16.0005
R3038 vdd.n931 vdd.n928 16.0005
R3039 vdd.n928 vdd.n925 16.0005
R3040 vdd.n925 vdd.n922 16.0005
R3041 vdd.n922 vdd.n919 16.0005
R3042 vdd.n919 vdd.n916 16.0005
R3043 vdd.n916 vdd.n913 16.0005
R3044 vdd.n913 vdd.n910 16.0005
R3045 vdd.n910 vdd.n907 16.0005
R3046 vdd.n907 vdd.n904 16.0005
R3047 vdd.n904 vdd.n901 16.0005
R3048 vdd.n901 vdd.n898 16.0005
R3049 vdd.n937 vdd.n895 189.355
R3050 vdd.n938 vdd.n939 2.68753
R3051 vdd.n939 vdd.n940 0.15675
R3052 vdd.n940 vdd.n941 0.15675
R3053 vdd.n941 vdd.n942 0.15675
R3054 vdd.n942 vdd.n943 0.15675
R3055 vdd.n943 vdd.n944 0.15675
R3056 vdd.n944 vdd.n945 0.15675
R3057 vdd.n945 vdd.n946 0.15675
R3058 vdd.n946 vdd.n947 0.15675
R3059 vdd.n947 vdd.n948 0.15675
R3060 vdd.n948 vdd.n949 0.15675
R3061 vdd.n949 vdd.n937 2.68753
R3062 vdd.n936 vdd.n933 114.001
R3063 vdd.n933 vdd.n930 114.001
R3064 vdd.n930 vdd.n927 114.001
R3065 vdd.n927 vdd.n924 114.001
R3066 vdd.n924 vdd.n921 114.001
R3067 vdd.n921 vdd.n918 114.001
R3068 vdd.n918 vdd.n915 114.001
R3069 vdd.n915 vdd.n912 114.001
R3070 vdd.n912 vdd.n909 114.001
R3071 vdd.n909 vdd.n906 114.001
R3072 vdd.n906 vdd.n903 114.001
R3073 vdd.n903 vdd.n900 114.001
R3074 vdd.n900 vdd.n897 114.001
R3075 vdd.n897 vdd.n895 114.001
R3076 vdd.n895 vdd.n886 507.3
R3077 vdd.n886 vdd.n883 114.001
R3078 vdd.n883 vdd.n880 114.001
R3079 vdd.n880 vdd.n877 114.001
R3080 vdd.n877 vdd.n874 114.001
R3081 vdd.n874 vdd.n871 114.001
R3082 vdd.n871 vdd.n868 114.001
R3083 vdd.n868 vdd.n865 114.001
R3084 vdd.n865 vdd.n863 114.001
R3085 vdd.n863 vdd.n858 495.901
R3086 vdd.n858 vdd.n855 114.001
R3087 vdd.n855 vdd.n852 114.001
R3088 vdd.n852 vdd.n849 114.001
R3089 vdd.n849 vdd.n847 114.001
R3090 vdd.n884 vdd.n888 4.28224
R3091 vdd.n881 vdd.n889 9.3005
R3092 vdd.n878 vdd.n890 9.3005
R3093 vdd.n875 vdd.n891 9.3005
R3094 vdd.n872 vdd.n892 9.3005
R3095 vdd.n869 vdd.n893 9.3005
R3096 vdd.n866 vdd.n887 4.28224
R3097 vdd.n886 vdd.n888 189.355
R3098 vdd.n884 vdd.n881 16.0005
R3099 vdd.n881 vdd.n878 16.0005
R3100 vdd.n878 vdd.n875 16.0005
R3101 vdd.n875 vdd.n872 16.0005
R3102 vdd.n872 vdd.n869 16.0005
R3103 vdd.n869 vdd.n866 16.0005
R3104 vdd.n887 vdd.n863 189.355
R3105 vdd.n888 vdd.n889 2.68753
R3106 vdd.n889 vdd.n890 0.15675
R3107 vdd.n890 vdd.n891 0.15675
R3108 vdd.n891 vdd.n892 0.15675
R3109 vdd.n892 vdd.n893 0.15675
R3110 vdd.n893 vdd.n887 2.68753
R3111 vdd.n856 vdd.n860 4.28224
R3112 vdd.n853 vdd.n861 9.3005
R3113 vdd.n850 vdd.n859 4.28224
R3114 vdd.n858 vdd.n860 189.355
R3115 vdd.n856 vdd.n853 16.0005
R3116 vdd.n853 vdd.n850 16.0005
R3117 vdd.n859 vdd.n847 189.355
R3118 vdd.n860 vdd.n861 2.68753
R3119 vdd.n859 vdd.n861 2.68753
R3120 vdd.n707 vdd.t22 29.1857
R3121 vdd.n706 vdd.n645 11.9261
R3122 vdd.n647 vdd.n646 9.3005
R3123 vdd.n648 vdd.n649 3.56667
R3124 vdd.n705 vdd.n650 9.3005
R3125 vdd.n705 vdd.n648 2.99921
R3126 vdd.n647 vdd.n705 0.114136
R3127 vdd.n645 vdd.n647 0.134591
R3128 vdd.n655 vdd.n654 68.9104
R3129 vdd.n654 vdd.n651 47.1822
R3130 vdd.n650 vdd.n651 185
R3131 vdd.n653 vdd.n655 68.9104
R3132 vdd.n649 vdd.n652 185
R3133 vdd.n653 vdd.n648 235.792
R3134 vdd.n649 vdd.n650 11.6369
R3135 vdd.n650 vdd.n646 11.6369
R3136 vdd.n652 vdd.n653 47.1822
R3137 vdd.n652 vdd.n651 126.668
R3138 vdd.n646 vdd.n654 232.183
R3139 vdd.n657 vdd.n658 232.183
R3140 vdd.n656 vdd.n658 68.9104
R3141 vdd.n660 vdd.n659 185
R3142 vdd.n661 vdd.n663 47.1822
R3143 vdd.n662 vdd.n661 185
R3144 vdd.n663 vdd.n656 68.9104
R3145 vdd.n656 vdd.t4 1300.31
R3146 vdd.n656 vdd.t2 1644.69
R3147 vdd.n655 vdd.t2 1300.31
R3148 vdd.n664 vdd.n657 9.3005
R3149 vdd.n665 vdd.n662 3.56667
R3150 vdd.n704 vdd.n660 9.3005
R3151 vdd.n662 vdd.n660 11.6369
R3152 vdd.n660 vdd.n657 11.6369
R3153 vdd.n704 vdd.n665 2.99921
R3154 vdd.n664 vdd.n704 0.114136
R3155 vdd.n703 vdd.n664 0.134591
R3156 vdd.n668 vdd.n667 9.3005
R3157 vdd.n670 vdd.n669 9.3005
R3158 vdd.n672 vdd.n671 9.3005
R3159 vdd.n674 vdd.n673 9.3005
R3160 vdd.n676 vdd.n675 9.3005
R3161 vdd.n678 vdd.n677 9.3005
R3162 vdd.n680 vdd.n679 9.3005
R3163 vdd.n682 vdd.n681 9.3005
R3164 vdd.n684 vdd.n683 9.3005
R3165 vdd.n686 vdd.n685 9.3005
R3166 vdd.n688 vdd.n687 9.3005
R3167 vdd.n690 vdd.n689 9.3005
R3168 vdd.n692 vdd.n691 9.3005
R3169 vdd.n702 vdd.n693 9.3005
R3170 vdd.n666 vdd.n703 0.982946
R3171 vdd.n702 vdd.n666 0.154821
R3172 vdd.n692 vdd.n702 0.154821
R3173 vdd.n690 vdd.n692 0.154821
R3174 vdd.n688 vdd.n690 0.154821
R3175 vdd.n686 vdd.n688 0.154821
R3176 vdd.n684 vdd.n686 0.154821
R3177 vdd.n682 vdd.n684 0.154821
R3178 vdd.n680 vdd.n682 0.154821
R3179 vdd.n678 vdd.n680 0.154821
R3180 vdd.n676 vdd.n678 0.154821
R3181 vdd.n674 vdd.n676 0.154821
R3182 vdd.n672 vdd.n674 0.154821
R3183 vdd.n670 vdd.n672 0.154821
R3184 vdd.n668 vdd.n670 0.154821
R3185 vdd.n645 vdd.n668 0.529821
R3186 vdd.n694 vdd.n666 17.8237
R3187 vdd.n701 vdd.n694 288.24
R3188 vdd.n695 vdd.n691 8.52365
R3189 vdd.n701 vdd.n695 288.24
R3190 vdd.n696 vdd.n687 8.52365
R3191 vdd.n701 vdd.n696 288.24
R3192 vdd.n697 vdd.n683 8.52365
R3193 vdd.n701 vdd.n697 288.24
R3194 vdd.n698 vdd.n679 8.52365
R3195 vdd.n701 vdd.n698 288.24
R3196 vdd.n699 vdd.n675 8.52365
R3197 vdd.n701 vdd.n699 288.24
R3198 vdd.n700 vdd.n671 8.52365
R3199 vdd.n700 vdd.n701 288.24
R3200 vdd.n701 vdd.n667 585
R3201 vdd.n693 vdd.n694 8.52365
R3202 vdd.n693 vdd.n691 17.2978
R3203 vdd.n689 vdd.n695 8.52365
R3204 vdd.n689 vdd.n687 17.2978
R3205 vdd.n685 vdd.n696 8.52365
R3206 vdd.n685 vdd.n683 17.2978
R3207 vdd.n681 vdd.n697 8.52365
R3208 vdd.n681 vdd.n679 17.2978
R3209 vdd.n677 vdd.n698 8.52365
R3210 vdd.n677 vdd.n675 17.2978
R3211 vdd.n673 vdd.n699 8.52365
R3212 vdd.n673 vdd.n671 17.2978
R3213 vdd.n669 vdd.n700 8.52365
R3214 vdd.n669 vdd.n667 17.2978
R3215 vdd.n701 vdd.t3 7.99863
R3216 vdd.n703 vdd.t5 48.8452
R3217 vdd.n665 vdd.n663 235.792
R3218 vdd.n661 vdd.n659 126.668
R3219 vdd.n659 vdd.n658 47.1822
R3220 vdd.n644 vdd.n627 14.4261
R3221 vdd.n628 vdd.n69 9.3005
R3222 vdd.n629 vdd.n103 3.56667
R3223 vdd.n630 vdd.n101 9.3005
R3224 vdd.n631 vdd.n98 9.3005
R3225 vdd.n632 vdd.n96 9.3005
R3226 vdd.n633 vdd.n93 9.3005
R3227 vdd.n634 vdd.n91 9.3005
R3228 vdd.n635 vdd.n88 9.3005
R3229 vdd.n636 vdd.n86 9.3005
R3230 vdd.n637 vdd.n83 9.3005
R3231 vdd.n638 vdd.n81 9.3005
R3232 vdd.n639 vdd.n78 9.3005
R3233 vdd.n640 vdd.n76 9.3005
R3234 vdd.n641 vdd.n73 9.3005
R3235 vdd.n643 vdd.n642 9.3005
R3236 vdd.n630 vdd.n629 2.99921
R3237 vdd.n631 vdd.n630 0.114136
R3238 vdd.n632 vdd.n631 0.114136
R3239 vdd.n633 vdd.n632 0.114136
R3240 vdd.n634 vdd.n633 0.114136
R3241 vdd.n635 vdd.n634 0.114136
R3242 vdd.n636 vdd.n635 0.114136
R3243 vdd.n637 vdd.n636 0.114136
R3244 vdd.n638 vdd.n637 0.114136
R3245 vdd.n639 vdd.n638 0.114136
R3246 vdd.n640 vdd.n639 0.114136
R3247 vdd.n641 vdd.n640 0.114136
R3248 vdd.n643 vdd.n641 0.114136
R3249 vdd.n628 vdd.n643 0.114136
R3250 vdd.n627 vdd.n628 0.134591
R3251 vdd.n103 vdd.n101 11.6369
R3252 vdd.n101 vdd.n98 11.6369
R3253 vdd.n98 vdd.n96 11.6369
R3254 vdd.n96 vdd.n93 11.6369
R3255 vdd.n93 vdd.n91 11.6369
R3256 vdd.n91 vdd.n88 11.6369
R3257 vdd.n88 vdd.n86 11.6369
R3258 vdd.n86 vdd.n83 11.6369
R3259 vdd.n83 vdd.n81 11.6369
R3260 vdd.n81 vdd.n78 11.6369
R3261 vdd.n78 vdd.n76 11.6369
R3262 vdd.n76 vdd.n73 11.6369
R3263 vdd.n73 vdd.n642 11.6369
R3264 vdd.n642 vdd.n69 11.6369
R3265 vdd.n627 vdd.n10 0.529821
R3266 vdd.n626 vdd.n574 13.3011
R3267 vdd.n575 vdd.n362 3.56667
R3268 vdd.n576 vdd.n359 9.3005
R3269 vdd.n577 vdd.n356 9.3005
R3270 vdd.n578 vdd.n353 9.3005
R3271 vdd.n579 vdd.n350 9.3005
R3272 vdd.n580 vdd.n347 9.3005
R3273 vdd.n581 vdd.n344 9.3005
R3274 vdd.n582 vdd.n341 9.3005
R3275 vdd.n583 vdd.n338 9.3005
R3276 vdd.n584 vdd.n335 9.3005
R3277 vdd.n585 vdd.n332 9.3005
R3278 vdd.n586 vdd.n329 9.3005
R3279 vdd.n587 vdd.n326 9.3005
R3280 vdd.n588 vdd.n323 9.3005
R3281 vdd.n589 vdd.n320 9.3005
R3282 vdd.n625 vdd.n624 9.3005
R3283 vdd.n576 vdd.n575 2.99921
R3284 vdd.n577 vdd.n576 0.114136
R3285 vdd.n578 vdd.n577 0.114136
R3286 vdd.n579 vdd.n578 0.114136
R3287 vdd.n580 vdd.n579 0.114136
R3288 vdd.n581 vdd.n580 0.114136
R3289 vdd.n582 vdd.n581 0.114136
R3290 vdd.n583 vdd.n582 0.114136
R3291 vdd.n584 vdd.n583 0.114136
R3292 vdd.n585 vdd.n584 0.114136
R3293 vdd.n586 vdd.n585 0.114136
R3294 vdd.n587 vdd.n586 0.114136
R3295 vdd.n588 vdd.n587 0.114136
R3296 vdd.n589 vdd.n588 0.114136
R3297 vdd.n574 vdd.n589 0.132318
R3298 vdd.n574 vdd.n625 0.208455
R3299 vdd.n591 vdd.n298 9.3005
R3300 vdd.n592 vdd.n296 9.3005
R3301 vdd.n593 vdd.n294 9.3005
R3302 vdd.n594 vdd.n292 9.3005
R3303 vdd.n595 vdd.n290 9.3005
R3304 vdd.n596 vdd.n288 9.3005
R3305 vdd.n597 vdd.n286 9.3005
R3306 vdd.n598 vdd.n284 9.3005
R3307 vdd.n599 vdd.n282 9.3005
R3308 vdd.n600 vdd.n280 9.3005
R3309 vdd.n601 vdd.n278 9.3005
R3310 vdd.n602 vdd.n276 9.3005
R3311 vdd.n603 vdd.n274 9.3005
R3312 vdd.n604 vdd.n272 9.3005
R3313 vdd.n605 vdd.n270 9.3005
R3314 vdd.n606 vdd.n268 9.3005
R3315 vdd.n607 vdd.n266 9.3005
R3316 vdd.n608 vdd.n264 9.3005
R3317 vdd.n609 vdd.n262 9.3005
R3318 vdd.n610 vdd.n260 9.3005
R3319 vdd.n611 vdd.n258 9.3005
R3320 vdd.n612 vdd.n256 9.3005
R3321 vdd.n613 vdd.n254 9.3005
R3322 vdd.n614 vdd.n252 9.3005
R3323 vdd.n615 vdd.n250 9.3005
R3324 vdd.n616 vdd.n248 9.3005
R3325 vdd.n617 vdd.n246 9.3005
R3326 vdd.n618 vdd.n244 9.3005
R3327 vdd.n619 vdd.n242 9.3005
R3328 vdd.n620 vdd.n240 9.3005
R3329 vdd.n621 vdd.n238 9.3005
R3330 vdd.n622 vdd.n236 9.3005
R3331 vdd.n590 vdd.n623 3.56667
R3332 vdd.n622 vdd.n590 2.99921
R3333 vdd.n621 vdd.n622 0.114136
R3334 vdd.n620 vdd.n621 0.114136
R3335 vdd.n619 vdd.n620 0.114136
R3336 vdd.n618 vdd.n619 0.114136
R3337 vdd.n617 vdd.n618 0.114136
R3338 vdd.n616 vdd.n617 0.114136
R3339 vdd.n615 vdd.n616 0.114136
R3340 vdd.n614 vdd.n615 0.114136
R3341 vdd.n613 vdd.n614 0.114136
R3342 vdd.n612 vdd.n613 0.114136
R3343 vdd.n611 vdd.n612 0.114136
R3344 vdd.n610 vdd.n611 0.114136
R3345 vdd.n609 vdd.n610 0.114136
R3346 vdd.n608 vdd.n609 0.114136
R3347 vdd.n607 vdd.n608 0.114136
R3348 vdd.n606 vdd.n607 0.114136
R3349 vdd.n605 vdd.n606 0.114136
R3350 vdd.n604 vdd.n605 0.114136
R3351 vdd.n603 vdd.n604 0.114136
R3352 vdd.n602 vdd.n603 0.114136
R3353 vdd.n601 vdd.n602 0.114136
R3354 vdd.n600 vdd.n601 0.114136
R3355 vdd.n599 vdd.n600 0.114136
R3356 vdd.n598 vdd.n599 0.114136
R3357 vdd.n597 vdd.n598 0.114136
R3358 vdd.n596 vdd.n597 0.114136
R3359 vdd.n595 vdd.n596 0.114136
R3360 vdd.n594 vdd.n595 0.114136
R3361 vdd.n593 vdd.n594 0.114136
R3362 vdd.n592 vdd.n593 0.114136
R3363 vdd.n591 vdd.n592 0.114136
R3364 vdd.n625 vdd.n591 0.108455
R3365 vdd.n299 vdd.n590 235.792
R3366 vdd.n623 vdd.n236 11.6369
R3367 vdd.n236 vdd.n238 11.6369
R3368 vdd.n238 vdd.n240 11.6369
R3369 vdd.n240 vdd.n242 11.6369
R3370 vdd.n242 vdd.n244 11.6369
R3371 vdd.n244 vdd.n246 11.6369
R3372 vdd.n246 vdd.n248 11.6369
R3373 vdd.n248 vdd.n250 11.6369
R3374 vdd.n250 vdd.n252 11.6369
R3375 vdd.n252 vdd.n254 11.6369
R3376 vdd.n254 vdd.n256 11.6369
R3377 vdd.n256 vdd.n258 11.6369
R3378 vdd.n258 vdd.n260 11.6369
R3379 vdd.n260 vdd.n262 11.6369
R3380 vdd.n262 vdd.n264 11.6369
R3381 vdd.n264 vdd.n266 11.6369
R3382 vdd.n266 vdd.n268 11.6369
R3383 vdd.n268 vdd.n270 11.6369
R3384 vdd.n270 vdd.n272 11.6369
R3385 vdd.n272 vdd.n274 11.6369
R3386 vdd.n274 vdd.n276 11.6369
R3387 vdd.n276 vdd.n278 11.6369
R3388 vdd.n278 vdd.n280 11.6369
R3389 vdd.n280 vdd.n282 11.6369
R3390 vdd.n282 vdd.n284 11.6369
R3391 vdd.n284 vdd.n286 11.6369
R3392 vdd.n286 vdd.n288 11.6369
R3393 vdd.n288 vdd.n290 11.6369
R3394 vdd.n290 vdd.n292 11.6369
R3395 vdd.n292 vdd.n294 11.6369
R3396 vdd.n294 vdd.n296 11.6369
R3397 vdd.n296 vdd.n298 11.6369
R3398 vdd.n298 vdd.n624 11.055
R3399 vdd.n575 vdd.n364 188.611
R3400 vdd.n362 vdd.n359 11.6369
R3401 vdd.n359 vdd.n356 11.6369
R3402 vdd.n356 vdd.n353 11.6369
R3403 vdd.n353 vdd.n350 11.6369
R3404 vdd.n350 vdd.n347 11.6369
R3405 vdd.n347 vdd.n344 11.6369
R3406 vdd.n344 vdd.n341 11.6369
R3407 vdd.n341 vdd.n338 11.6369
R3408 vdd.n338 vdd.n335 11.6369
R3409 vdd.n335 vdd.n332 11.6369
R3410 vdd.n332 vdd.n329 11.6369
R3411 vdd.n329 vdd.n326 11.6369
R3412 vdd.n326 vdd.n323 11.6369
R3413 vdd.n323 vdd.n320 11.6369
R3414 vdd.n320 vdd.n624 34.7932
R3415 vdd.n574 vdd.t13 25.1983
R3416 vdd.n626 vdd.n522 14.4658
R3417 vdd.n523 vdd.n233 3.56667
R3418 vdd.n524 vdd.n230 9.3005
R3419 vdd.n525 vdd.n227 9.3005
R3420 vdd.n526 vdd.n224 9.3005
R3421 vdd.n527 vdd.n221 9.3005
R3422 vdd.n528 vdd.n218 9.3005
R3423 vdd.n529 vdd.n215 9.3005
R3424 vdd.n530 vdd.n212 9.3005
R3425 vdd.n531 vdd.n209 9.3005
R3426 vdd.n532 vdd.n206 9.3005
R3427 vdd.n533 vdd.n203 9.3005
R3428 vdd.n534 vdd.n200 9.3005
R3429 vdd.n535 vdd.n197 9.3005
R3430 vdd.n536 vdd.n194 9.3005
R3431 vdd.n537 vdd.n191 9.3005
R3432 vdd.n573 vdd.n572 9.3005
R3433 vdd.n524 vdd.n523 2.99921
R3434 vdd.n525 vdd.n524 0.114136
R3435 vdd.n526 vdd.n525 0.114136
R3436 vdd.n527 vdd.n526 0.114136
R3437 vdd.n528 vdd.n527 0.114136
R3438 vdd.n529 vdd.n528 0.114136
R3439 vdd.n530 vdd.n529 0.114136
R3440 vdd.n531 vdd.n530 0.114136
R3441 vdd.n532 vdd.n531 0.114136
R3442 vdd.n533 vdd.n532 0.114136
R3443 vdd.n534 vdd.n533 0.114136
R3444 vdd.n535 vdd.n534 0.114136
R3445 vdd.n536 vdd.n535 0.114136
R3446 vdd.n537 vdd.n536 0.114136
R3447 vdd.n522 vdd.n537 0.134591
R3448 vdd.n522 vdd.n573 0.206182
R3449 vdd.n539 vdd.n169 9.3005
R3450 vdd.n540 vdd.n167 9.3005
R3451 vdd.n541 vdd.n165 9.3005
R3452 vdd.n542 vdd.n163 9.3005
R3453 vdd.n543 vdd.n161 9.3005
R3454 vdd.n544 vdd.n159 9.3005
R3455 vdd.n545 vdd.n157 9.3005
R3456 vdd.n546 vdd.n155 9.3005
R3457 vdd.n547 vdd.n153 9.3005
R3458 vdd.n548 vdd.n151 9.3005
R3459 vdd.n549 vdd.n149 9.3005
R3460 vdd.n550 vdd.n147 9.3005
R3461 vdd.n551 vdd.n145 9.3005
R3462 vdd.n552 vdd.n143 9.3005
R3463 vdd.n553 vdd.n141 9.3005
R3464 vdd.n554 vdd.n139 9.3005
R3465 vdd.n555 vdd.n137 9.3005
R3466 vdd.n556 vdd.n135 9.3005
R3467 vdd.n557 vdd.n133 9.3005
R3468 vdd.n558 vdd.n131 9.3005
R3469 vdd.n559 vdd.n129 9.3005
R3470 vdd.n560 vdd.n127 9.3005
R3471 vdd.n561 vdd.n125 9.3005
R3472 vdd.n562 vdd.n123 9.3005
R3473 vdd.n563 vdd.n121 9.3005
R3474 vdd.n564 vdd.n119 9.3005
R3475 vdd.n565 vdd.n117 9.3005
R3476 vdd.n566 vdd.n115 9.3005
R3477 vdd.n567 vdd.n113 9.3005
R3478 vdd.n568 vdd.n111 9.3005
R3479 vdd.n569 vdd.n109 9.3005
R3480 vdd.n570 vdd.n107 9.3005
R3481 vdd.n538 vdd.n571 3.56667
R3482 vdd.n570 vdd.n538 2.99921
R3483 vdd.n569 vdd.n570 0.114136
R3484 vdd.n568 vdd.n569 0.114136
R3485 vdd.n567 vdd.n568 0.114136
R3486 vdd.n566 vdd.n567 0.114136
R3487 vdd.n565 vdd.n566 0.114136
R3488 vdd.n564 vdd.n565 0.114136
R3489 vdd.n563 vdd.n564 0.114136
R3490 vdd.n562 vdd.n563 0.114136
R3491 vdd.n561 vdd.n562 0.114136
R3492 vdd.n560 vdd.n561 0.114136
R3493 vdd.n559 vdd.n560 0.114136
R3494 vdd.n558 vdd.n559 0.114136
R3495 vdd.n557 vdd.n558 0.114136
R3496 vdd.n556 vdd.n557 0.114136
R3497 vdd.n555 vdd.n556 0.114136
R3498 vdd.n554 vdd.n555 0.114136
R3499 vdd.n553 vdd.n554 0.114136
R3500 vdd.n552 vdd.n553 0.114136
R3501 vdd.n551 vdd.n552 0.114136
R3502 vdd.n550 vdd.n551 0.114136
R3503 vdd.n549 vdd.n550 0.114136
R3504 vdd.n548 vdd.n549 0.114136
R3505 vdd.n547 vdd.n548 0.114136
R3506 vdd.n546 vdd.n547 0.114136
R3507 vdd.n545 vdd.n546 0.114136
R3508 vdd.n544 vdd.n545 0.114136
R3509 vdd.n543 vdd.n544 0.114136
R3510 vdd.n542 vdd.n543 0.114136
R3511 vdd.n541 vdd.n542 0.114136
R3512 vdd.n540 vdd.n541 0.114136
R3513 vdd.n539 vdd.n540 0.114136
R3514 vdd.n573 vdd.n539 0.108455
R3515 vdd.n170 vdd.n538 235.792
R3516 vdd.n571 vdd.n107 11.6369
R3517 vdd.n107 vdd.n109 11.6369
R3518 vdd.n109 vdd.n111 11.6369
R3519 vdd.n111 vdd.n113 11.6369
R3520 vdd.n113 vdd.n115 11.6369
R3521 vdd.n115 vdd.n117 11.6369
R3522 vdd.n117 vdd.n119 11.6369
R3523 vdd.n119 vdd.n121 11.6369
R3524 vdd.n121 vdd.n123 11.6369
R3525 vdd.n123 vdd.n125 11.6369
R3526 vdd.n125 vdd.n127 11.6369
R3527 vdd.n127 vdd.n129 11.6369
R3528 vdd.n129 vdd.n131 11.6369
R3529 vdd.n131 vdd.n133 11.6369
R3530 vdd.n133 vdd.n135 11.6369
R3531 vdd.n135 vdd.n137 11.6369
R3532 vdd.n137 vdd.n139 11.6369
R3533 vdd.n139 vdd.n141 11.6369
R3534 vdd.n141 vdd.n143 11.6369
R3535 vdd.n143 vdd.n145 11.6369
R3536 vdd.n145 vdd.n147 11.6369
R3537 vdd.n147 vdd.n149 11.6369
R3538 vdd.n149 vdd.n151 11.6369
R3539 vdd.n151 vdd.n153 11.6369
R3540 vdd.n153 vdd.n155 11.6369
R3541 vdd.n155 vdd.n157 11.6369
R3542 vdd.n157 vdd.n159 11.6369
R3543 vdd.n159 vdd.n161 11.6369
R3544 vdd.n161 vdd.n163 11.6369
R3545 vdd.n163 vdd.n165 11.6369
R3546 vdd.n165 vdd.n167 11.6369
R3547 vdd.n167 vdd.n169 11.6369
R3548 vdd.n169 vdd.n572 11.055
R3549 vdd.n231 vdd.n523 239.639
R3550 vdd.n233 vdd.n230 11.6369
R3551 vdd.n230 vdd.n227 11.6369
R3552 vdd.n227 vdd.n224 11.6369
R3553 vdd.n224 vdd.n221 11.6369
R3554 vdd.n221 vdd.n218 11.6369
R3555 vdd.n218 vdd.n215 11.6369
R3556 vdd.n215 vdd.n212 11.6369
R3557 vdd.n212 vdd.n209 11.6369
R3558 vdd.n209 vdd.n206 11.6369
R3559 vdd.n206 vdd.n203 11.6369
R3560 vdd.n203 vdd.n200 11.6369
R3561 vdd.n200 vdd.n197 11.6369
R3562 vdd.n197 vdd.n194 11.6369
R3563 vdd.n194 vdd.n191 11.6369
R3564 vdd.n191 vdd.n572 34.7932
R3565 vdd.n522 vdd.t11 25.1983
R3566 vdd.n470 vdd.n469 9.3005
R3567 vdd.n472 vdd.n471 9.3005
R3568 vdd.n474 vdd.n473 9.3005
R3569 vdd.n476 vdd.n475 9.3005
R3570 vdd.n478 vdd.n477 9.3005
R3571 vdd.n480 vdd.n479 9.3005
R3572 vdd.n482 vdd.n481 9.3005
R3573 vdd.n484 vdd.n483 9.3005
R3574 vdd.n486 vdd.n485 9.3005
R3575 vdd.n488 vdd.n487 9.3005
R3576 vdd.n490 vdd.n489 9.3005
R3577 vdd.n492 vdd.n491 9.3005
R3578 vdd.n494 vdd.n493 9.3005
R3579 vdd.n504 vdd.n495 9.3005
R3580 vdd.n504 vdd.n468 0.154821
R3581 vdd.n494 vdd.n504 0.154821
R3582 vdd.n492 vdd.n494 0.154821
R3583 vdd.n490 vdd.n492 0.154821
R3584 vdd.n488 vdd.n490 0.154821
R3585 vdd.n486 vdd.n488 0.154821
R3586 vdd.n484 vdd.n486 0.154821
R3587 vdd.n482 vdd.n484 0.154821
R3588 vdd.n480 vdd.n482 0.154821
R3589 vdd.n478 vdd.n480 0.154821
R3590 vdd.n476 vdd.n478 0.154821
R3591 vdd.n474 vdd.n476 0.154821
R3592 vdd.n472 vdd.n474 0.154821
R3593 vdd.n470 vdd.n472 0.154821
R3594 vdd.n1734 vdd.n470 0.529821
R3595 vdd.n468 vdd.n505 0.982946
R3596 vdd.n506 vdd.n367 9.3005
R3597 vdd.n507 vdd.n408 3.56667
R3598 vdd.n508 vdd.n405 9.3005
R3599 vdd.n509 vdd.n402 9.3005
R3600 vdd.n510 vdd.n399 9.3005
R3601 vdd.n511 vdd.n396 9.3005
R3602 vdd.n512 vdd.n393 9.3005
R3603 vdd.n513 vdd.n390 9.3005
R3604 vdd.n514 vdd.n387 9.3005
R3605 vdd.n515 vdd.n384 9.3005
R3606 vdd.n516 vdd.n381 9.3005
R3607 vdd.n517 vdd.n378 9.3005
R3608 vdd.n518 vdd.n375 9.3005
R3609 vdd.n519 vdd.n372 9.3005
R3610 vdd.n521 vdd.n520 9.3005
R3611 vdd.n508 vdd.n507 2.99921
R3612 vdd.n509 vdd.n508 0.114136
R3613 vdd.n510 vdd.n509 0.114136
R3614 vdd.n511 vdd.n510 0.114136
R3615 vdd.n512 vdd.n511 0.114136
R3616 vdd.n513 vdd.n512 0.114136
R3617 vdd.n514 vdd.n513 0.114136
R3618 vdd.n515 vdd.n514 0.114136
R3619 vdd.n516 vdd.n515 0.114136
R3620 vdd.n517 vdd.n516 0.114136
R3621 vdd.n518 vdd.n517 0.114136
R3622 vdd.n519 vdd.n518 0.114136
R3623 vdd.n521 vdd.n519 0.114136
R3624 vdd.n506 vdd.n521 0.114136
R3625 vdd.n505 vdd.n506 0.132318
R3626 vdd.n507 vdd.n410 188.611
R3627 vdd.n408 vdd.n405 11.6369
R3628 vdd.n405 vdd.n402 11.6369
R3629 vdd.n402 vdd.n399 11.6369
R3630 vdd.n399 vdd.n396 11.6369
R3631 vdd.n396 vdd.n393 11.6369
R3632 vdd.n393 vdd.n390 11.6369
R3633 vdd.n390 vdd.n387 11.6369
R3634 vdd.n387 vdd.n384 11.6369
R3635 vdd.n384 vdd.n381 11.6369
R3636 vdd.n381 vdd.n378 11.6369
R3637 vdd.n378 vdd.n375 11.6369
R3638 vdd.n375 vdd.n372 11.6369
R3639 vdd.n372 vdd.n520 11.6369
R3640 vdd.n520 vdd.n367 11.6369
R3641 vdd.n505 vdd.t18 48.8452
R3642 vdd.n496 vdd.n468 17.8237
R3643 vdd.n503 vdd.n496 288.24
R3644 vdd.n497 vdd.n493 8.52365
R3645 vdd.n503 vdd.n497 288.24
R3646 vdd.n498 vdd.n489 8.52365
R3647 vdd.n503 vdd.n498 288.24
R3648 vdd.n499 vdd.n485 8.52365
R3649 vdd.n503 vdd.n499 288.24
R3650 vdd.n500 vdd.n481 8.52365
R3651 vdd.n503 vdd.n500 288.24
R3652 vdd.n501 vdd.n477 8.52365
R3653 vdd.n503 vdd.n501 288.24
R3654 vdd.n502 vdd.n473 8.52365
R3655 vdd.n502 vdd.n503 288.24
R3656 vdd.n503 vdd.n469 585
R3657 vdd.n495 vdd.n496 8.52365
R3658 vdd.n495 vdd.n493 17.2978
R3659 vdd.n491 vdd.n497 8.52365
R3660 vdd.n491 vdd.n489 17.2978
R3661 vdd.n487 vdd.n498 8.52365
R3662 vdd.n487 vdd.n485 17.2978
R3663 vdd.n483 vdd.n499 8.52365
R3664 vdd.n483 vdd.n481 17.2978
R3665 vdd.n479 vdd.n500 8.52365
R3666 vdd.n479 vdd.n477 17.2978
R3667 vdd.n475 vdd.n501 8.52365
R3668 vdd.n475 vdd.n473 17.2978
R3669 vdd.n471 vdd.n502 8.52365
R3670 vdd.n471 vdd.n469 17.2978
R3671 vdd.n503 vdd.t15 7.99863
R3672 vdd.n454 vdd.n411 249.984
R3673 vdd.n412 vdd.n415 126.668
R3674 vdd.n415 vdd.n418 126.668
R3675 vdd.n418 vdd.n421 126.668
R3676 vdd.n421 vdd.n424 126.668
R3677 vdd.n424 vdd.n427 126.668
R3678 vdd.n427 vdd.n430 126.668
R3679 vdd.n430 vdd.n433 126.668
R3680 vdd.n433 vdd.n436 126.668
R3681 vdd.n436 vdd.n439 126.668
R3682 vdd.n439 vdd.n442 126.668
R3683 vdd.n442 vdd.n445 126.668
R3684 vdd.n445 vdd.n448 126.668
R3685 vdd.n448 vdd.n451 126.668
R3686 vdd.n451 vdd.n450 38.758
R3687 vdd.n410 vdd.n407 126.668
R3688 vdd.n407 vdd.n404 126.668
R3689 vdd.n404 vdd.n401 126.668
R3690 vdd.n401 vdd.n398 126.668
R3691 vdd.n398 vdd.n395 126.668
R3692 vdd.n395 vdd.n392 126.668
R3693 vdd.n392 vdd.n389 126.668
R3694 vdd.n389 vdd.n386 126.668
R3695 vdd.n386 vdd.n383 126.668
R3696 vdd.n383 vdd.n380 126.668
R3697 vdd.n380 vdd.n377 126.668
R3698 vdd.n377 vdd.n374 126.668
R3699 vdd.n374 vdd.n371 126.668
R3700 vdd.n371 vdd.n369 126.668
R3701 vdd.n369 vdd.n366 126.668
R3702 vdd.n364 vdd.n361 126.668
R3703 vdd.n361 vdd.n358 126.668
R3704 vdd.n358 vdd.n355 126.668
R3705 vdd.n355 vdd.n352 126.668
R3706 vdd.n352 vdd.n349 126.668
R3707 vdd.n349 vdd.n346 126.668
R3708 vdd.n346 vdd.n343 126.668
R3709 vdd.n343 vdd.n340 126.668
R3710 vdd.n340 vdd.n337 126.668
R3711 vdd.n337 vdd.n334 126.668
R3712 vdd.n334 vdd.n331 126.668
R3713 vdd.n331 vdd.n328 126.668
R3714 vdd.n328 vdd.n325 126.668
R3715 vdd.n325 vdd.n322 126.668
R3716 vdd.n322 vdd.n319 126.668
R3717 vdd.n234 vdd.n299 47.1822
R3718 vdd.n234 vdd.n235 126.668
R3719 vdd.n237 vdd.n300 47.1822
R3720 vdd.n237 vdd.n239 126.668
R3721 vdd.n241 vdd.n301 47.1822
R3722 vdd.n241 vdd.n243 126.668
R3723 vdd.n245 vdd.n302 47.1822
R3724 vdd.n245 vdd.n247 126.668
R3725 vdd.n249 vdd.n303 47.1822
R3726 vdd.n249 vdd.n251 126.668
R3727 vdd.n253 vdd.n304 47.1822
R3728 vdd.n253 vdd.n255 126.668
R3729 vdd.n257 vdd.n305 47.1822
R3730 vdd.n257 vdd.n259 126.668
R3731 vdd.n261 vdd.n306 47.1822
R3732 vdd.n261 vdd.n263 126.668
R3733 vdd.n265 vdd.n307 47.1822
R3734 vdd.n265 vdd.n267 126.668
R3735 vdd.n269 vdd.n308 47.1822
R3736 vdd.n269 vdd.n271 126.668
R3737 vdd.n273 vdd.n309 47.1822
R3738 vdd.n273 vdd.n275 126.668
R3739 vdd.n277 vdd.n310 47.1822
R3740 vdd.n277 vdd.n279 126.668
R3741 vdd.n281 vdd.n311 47.1822
R3742 vdd.n281 vdd.n283 126.668
R3743 vdd.n285 vdd.n312 47.1822
R3744 vdd.n285 vdd.n287 126.668
R3745 vdd.n289 vdd.n313 47.1822
R3746 vdd.n289 vdd.n291 126.668
R3747 vdd.n293 vdd.n314 47.1822
R3748 vdd.n293 vdd.n295 126.668
R3749 vdd.n295 vdd.n297 126.668
R3750 vdd.n317 vdd.n316 47.1822
R3751 vdd.n317 vdd.n319 385.067
R3752 vdd.n232 vdd.n231 44.8982
R3753 vdd.n232 vdd.n229 126.668
R3754 vdd.n229 vdd.n226 126.668
R3755 vdd.n226 vdd.n223 126.668
R3756 vdd.n223 vdd.n220 126.668
R3757 vdd.n220 vdd.n217 126.668
R3758 vdd.n217 vdd.n214 126.668
R3759 vdd.n214 vdd.n211 126.668
R3760 vdd.n211 vdd.n208 126.668
R3761 vdd.n208 vdd.n205 126.668
R3762 vdd.n205 vdd.n202 126.668
R3763 vdd.n202 vdd.n199 126.668
R3764 vdd.n199 vdd.n196 126.668
R3765 vdd.n196 vdd.n193 126.668
R3766 vdd.n193 vdd.n190 126.668
R3767 vdd.n105 vdd.n170 47.1822
R3768 vdd.n105 vdd.n106 126.668
R3769 vdd.n108 vdd.n171 47.1822
R3770 vdd.n108 vdd.n110 126.668
R3771 vdd.n112 vdd.n172 47.1822
R3772 vdd.n112 vdd.n114 126.668
R3773 vdd.n116 vdd.n173 47.1822
R3774 vdd.n116 vdd.n118 126.668
R3775 vdd.n120 vdd.n174 47.1822
R3776 vdd.n120 vdd.n122 126.668
R3777 vdd.n124 vdd.n175 47.1822
R3778 vdd.n124 vdd.n126 126.668
R3779 vdd.n128 vdd.n176 47.1822
R3780 vdd.n128 vdd.n130 126.668
R3781 vdd.n132 vdd.n177 47.1822
R3782 vdd.n132 vdd.n134 126.668
R3783 vdd.n136 vdd.n178 47.1822
R3784 vdd.n136 vdd.n138 126.668
R3785 vdd.n140 vdd.n179 47.1822
R3786 vdd.n140 vdd.n142 126.668
R3787 vdd.n144 vdd.n180 47.1822
R3788 vdd.n144 vdd.n146 126.668
R3789 vdd.n148 vdd.n181 47.1822
R3790 vdd.n148 vdd.n150 126.668
R3791 vdd.n152 vdd.n182 47.1822
R3792 vdd.n152 vdd.n154 126.668
R3793 vdd.n156 vdd.n183 47.1822
R3794 vdd.n156 vdd.n158 126.668
R3795 vdd.n160 vdd.n184 47.1822
R3796 vdd.n160 vdd.n162 126.668
R3797 vdd.n164 vdd.n185 47.1822
R3798 vdd.n164 vdd.n166 126.668
R3799 vdd.n166 vdd.n168 126.668
R3800 vdd.n188 vdd.n187 47.1822
R3801 vdd.n188 vdd.n190 385.067
R3802 vdd.n629 vdd.n104 235.792
R3803 vdd.n102 vdd.n100 126.668
R3804 vdd.n100 vdd.n99 47.1822
R3805 vdd.n97 vdd.n95 126.668
R3806 vdd.n95 vdd.n94 47.1822
R3807 vdd.n92 vdd.n90 126.668
R3808 vdd.n90 vdd.n89 47.1822
R3809 vdd.n87 vdd.n85 126.668
R3810 vdd.n85 vdd.n84 47.1822
R3811 vdd.n82 vdd.n80 126.668
R3812 vdd.n80 vdd.n79 47.1822
R3813 vdd.n77 vdd.n75 126.668
R3814 vdd.n75 vdd.n74 47.1822
R3815 vdd.n72 vdd.n71 126.668
R3816 vdd.n71 vdd.n70 47.1822
R3817 vdd.n15 vdd.t26 101.716
R3818 nc2.n0 nc2.t1 1100
R3819 nc2 nc2.t1 0.0005
R3820 nb0.n0 nb0.t1 1100
R3821 nb0 nb0.t1 0.0005
R3822 dw_12460_11350.n382 dw_12460_11350.t5 375.515
R3823 dw_12460_11350.n382 dw_12460_11350.t6 374.265
R3824 dw_12460_11350.n235 dw_12460_11350.n233 185
R3825 dw_12460_11350.n234 dw_12460_11350.n87 185
R3826 dw_12460_11350.n231 dw_12460_11350.n87 185
R3827 dw_12460_11350.n241 dw_12460_11350.n240 185
R3828 dw_12460_11350.n242 dw_12460_11350.n241 185
R3829 dw_12460_11350.n89 dw_12460_11350.n85 185
R3830 dw_12460_11350.n243 dw_12460_11350.n85 185
R3831 dw_12460_11350.n246 dw_12460_11350.n245 185
R3832 dw_12460_11350.n245 dw_12460_11350.n244 185
R3833 dw_12460_11350.n247 dw_12460_11350.n80 185
R3834 dw_12460_11350.n80 dw_12460_11350.n79 185
R3835 dw_12460_11350.n254 dw_12460_11350.n253 185
R3836 dw_12460_11350.n255 dw_12460_11350.n254 185
R3837 dw_12460_11350.n82 dw_12460_11350.n78 185
R3838 dw_12460_11350.n256 dw_12460_11350.n78 185
R3839 dw_12460_11350.n259 dw_12460_11350.n258 185
R3840 dw_12460_11350.n258 dw_12460_11350.n257 185
R3841 dw_12460_11350.n260 dw_12460_11350.n73 185
R3842 dw_12460_11350.n73 dw_12460_11350.n72 185
R3843 dw_12460_11350.n267 dw_12460_11350.n266 185
R3844 dw_12460_11350.n268 dw_12460_11350.n267 185
R3845 dw_12460_11350.n75 dw_12460_11350.n71 185
R3846 dw_12460_11350.n269 dw_12460_11350.n71 185
R3847 dw_12460_11350.n272 dw_12460_11350.n271 185
R3848 dw_12460_11350.n271 dw_12460_11350.n270 185
R3849 dw_12460_11350.n273 dw_12460_11350.n66 185
R3850 dw_12460_11350.n66 dw_12460_11350.n65 185
R3851 dw_12460_11350.n282 dw_12460_11350.n281 185
R3852 dw_12460_11350.n283 dw_12460_11350.n282 185
R3853 dw_12460_11350.n68 dw_12460_11350.n62 185
R3854 dw_12460_11350.n284 dw_12460_11350.n62 185
R3855 dw_12460_11350.n286 dw_12460_11350.n64 185
R3856 dw_12460_11350.n286 dw_12460_11350.n285 185
R3857 dw_12460_11350.n287 dw_12460_11350.n60 185
R3858 dw_12460_11350.n290 dw_12460_11350.n289 185
R3859 dw_12460_11350.n179 dw_12460_11350.n132 185
R3860 dw_12460_11350.n181 dw_12460_11350.n180 185
R3861 dw_12460_11350.n182 dw_12460_11350.n181 185
R3862 dw_12460_11350.n133 dw_12460_11350.n130 185
R3863 dw_12460_11350.n183 dw_12460_11350.n130 185
R3864 dw_12460_11350.n186 dw_12460_11350.n185 185
R3865 dw_12460_11350.n185 dw_12460_11350.n184 185
R3866 dw_12460_11350.n126 dw_12460_11350.n123 185
R3867 dw_12460_11350.n123 dw_12460_11350.n122 185
R3868 dw_12460_11350.n192 dw_12460_11350.n191 185
R3869 dw_12460_11350.n193 dw_12460_11350.n192 185
R3870 dw_12460_11350.n124 dw_12460_11350.n121 185
R3871 dw_12460_11350.n194 dw_12460_11350.n121 185
R3872 dw_12460_11350.n197 dw_12460_11350.n196 185
R3873 dw_12460_11350.n196 dw_12460_11350.n195 185
R3874 dw_12460_11350.n117 dw_12460_11350.n114 185
R3875 dw_12460_11350.n114 dw_12460_11350.n113 185
R3876 dw_12460_11350.n203 dw_12460_11350.n202 185
R3877 dw_12460_11350.n204 dw_12460_11350.n203 185
R3878 dw_12460_11350.n115 dw_12460_11350.n112 185
R3879 dw_12460_11350.n205 dw_12460_11350.n112 185
R3880 dw_12460_11350.n208 dw_12460_11350.n207 185
R3881 dw_12460_11350.n207 dw_12460_11350.n206 185
R3882 dw_12460_11350.n108 dw_12460_11350.n105 185
R3883 dw_12460_11350.n105 dw_12460_11350.n104 185
R3884 dw_12460_11350.n214 dw_12460_11350.n213 185
R3885 dw_12460_11350.n215 dw_12460_11350.n214 185
R3886 dw_12460_11350.n106 dw_12460_11350.n103 185
R3887 dw_12460_11350.n216 dw_12460_11350.n103 185
R3888 dw_12460_11350.n219 dw_12460_11350.n218 185
R3889 dw_12460_11350.n218 dw_12460_11350.n217 185
R3890 dw_12460_11350.n98 dw_12460_11350.n95 185
R3891 dw_12460_11350.n95 dw_12460_11350.n94 185
R3892 dw_12460_11350.n225 dw_12460_11350.n224 185
R3893 dw_12460_11350.n226 dw_12460_11350.n225 185
R3894 dw_12460_11350.n96 dw_12460_11350.n92 185
R3895 dw_12460_11350.n227 dw_12460_11350.n92 185
R3896 dw_12460_11350.n229 dw_12460_11350.n93 185
R3897 dw_12460_11350.n229 dw_12460_11350.n228 185
R3898 dw_12460_11350.n230 dw_12460_11350.n91 185
R3899 dw_12460_11350.n357 dw_12460_11350.n24 185
R3900 dw_12460_11350.n21 dw_12460_11350.n18 185
R3901 dw_12460_11350.n362 dw_12460_11350.n361 185
R3902 dw_12460_11350.n363 dw_12460_11350.n362 185
R3903 dw_12460_11350.n19 dw_12460_11350.n16 185
R3904 dw_12460_11350.n364 dw_12460_11350.n16 185
R3905 dw_12460_11350.n367 dw_12460_11350.n366 185
R3906 dw_12460_11350.n366 dw_12460_11350.n365 185
R3907 dw_12460_11350.n12 dw_12460_11350.n9 185
R3908 dw_12460_11350.n9 dw_12460_11350.n8 185
R3909 dw_12460_11350.n373 dw_12460_11350.n372 185
R3910 dw_12460_11350.n374 dw_12460_11350.n373 185
R3911 dw_12460_11350.n10 dw_12460_11350.n6 185
R3912 dw_12460_11350.n375 dw_12460_11350.n6 185
R3913 dw_12460_11350.n378 dw_12460_11350.n377 185
R3914 dw_12460_11350.n377 dw_12460_11350.n376 185
R3915 dw_12460_11350.n5 dw_12460_11350.n3 185
R3916 dw_12460_11350.n7 dw_12460_11350.n5 185
R3917 dw_12460_11350.n158 dw_12460_11350.n157 185
R3918 dw_12460_11350.n159 dw_12460_11350.n158 185
R3919 dw_12460_11350.n153 dw_12460_11350.n152 185
R3920 dw_12460_11350.n160 dw_12460_11350.n152 185
R3921 dw_12460_11350.n163 dw_12460_11350.n162 185
R3922 dw_12460_11350.n162 dw_12460_11350.n161 185
R3923 dw_12460_11350.n148 dw_12460_11350.n145 185
R3924 dw_12460_11350.n145 dw_12460_11350.n144 185
R3925 dw_12460_11350.n169 dw_12460_11350.n168 185
R3926 dw_12460_11350.n170 dw_12460_11350.n169 185
R3927 dw_12460_11350.n146 dw_12460_11350.n143 185
R3928 dw_12460_11350.n171 dw_12460_11350.n143 185
R3929 dw_12460_11350.n174 dw_12460_11350.n173 185
R3930 dw_12460_11350.n173 dw_12460_11350.n172 185
R3931 dw_12460_11350.n142 dw_12460_11350.n137 185
R3932 dw_12460_11350.n142 dw_12460_11350.n141 185
R3933 dw_12460_11350.n139 dw_12460_11350.n135 185
R3934 dw_12460_11350.n356 dw_12460_11350.n355 185
R3935 dw_12460_11350.n355 dw_12460_11350.n354 185
R3936 dw_12460_11350.n352 dw_12460_11350.n25 185
R3937 dw_12460_11350.n352 dw_12460_11350.n351 185
R3938 dw_12460_11350.n30 dw_12460_11350.n26 185
R3939 dw_12460_11350.n350 dw_12460_11350.n26 185
R3940 dw_12460_11350.n348 dw_12460_11350.n347 185
R3941 dw_12460_11350.n349 dw_12460_11350.n348 185
R3942 dw_12460_11350.n340 dw_12460_11350.n28 185
R3943 dw_12460_11350.n28 dw_12460_11350.n27 185
R3944 dw_12460_11350.n339 dw_12460_11350.n338 185
R3945 dw_12460_11350.n338 dw_12460_11350.n337 185
R3946 dw_12460_11350.n37 dw_12460_11350.n33 185
R3947 dw_12460_11350.n336 dw_12460_11350.n33 185
R3948 dw_12460_11350.n334 dw_12460_11350.n333 185
R3949 dw_12460_11350.n335 dw_12460_11350.n334 185
R3950 dw_12460_11350.n327 dw_12460_11350.n35 185
R3951 dw_12460_11350.n35 dw_12460_11350.n34 185
R3952 dw_12460_11350.n326 dw_12460_11350.n325 185
R3953 dw_12460_11350.n325 dw_12460_11350.n324 185
R3954 dw_12460_11350.n44 dw_12460_11350.n40 185
R3955 dw_12460_11350.n323 dw_12460_11350.n40 185
R3956 dw_12460_11350.n321 dw_12460_11350.n320 185
R3957 dw_12460_11350.n322 dw_12460_11350.n321 185
R3958 dw_12460_11350.n314 dw_12460_11350.n42 185
R3959 dw_12460_11350.n42 dw_12460_11350.n41 185
R3960 dw_12460_11350.n313 dw_12460_11350.n312 185
R3961 dw_12460_11350.n312 dw_12460_11350.n311 185
R3962 dw_12460_11350.n51 dw_12460_11350.n47 185
R3963 dw_12460_11350.n310 dw_12460_11350.n47 185
R3964 dw_12460_11350.n308 dw_12460_11350.n307 185
R3965 dw_12460_11350.n309 dw_12460_11350.n308 185
R3966 dw_12460_11350.n301 dw_12460_11350.n49 185
R3967 dw_12460_11350.n49 dw_12460_11350.n48 185
R3968 dw_12460_11350.n300 dw_12460_11350.n299 185
R3969 dw_12460_11350.n299 dw_12460_11350.n298 185
R3970 dw_12460_11350.n58 dw_12460_11350.n54 185
R3971 dw_12460_11350.n297 dw_12460_11350.n54 185
R3972 dw_12460_11350.n295 dw_12460_11350.n294 185
R3973 dw_12460_11350.n296 dw_12460_11350.n295 185
R3974 dw_12460_11350.n57 dw_12460_11350.n56 185
R3975 dw_12460_11350.n61 dw_12460_11350.n56 185
R3976 dw_12460_11350.n296 dw_12460_11350.n55 184.722
R3977 dw_12460_11350.n351 dw_12460_11350.n17 184.722
R3978 dw_12460_11350.n228 dw_12460_11350.n86 184.722
R3979 dw_12460_11350.n182 dw_12460_11350.n131 184.722
R3980 dw_12460_11350.n172 dw_12460_11350.n171 179.445
R3981 dw_12460_11350.n171 dw_12460_11350.n170 179.445
R3982 dw_12460_11350.n170 dw_12460_11350.n144 179.445
R3983 dw_12460_11350.n161 dw_12460_11350.n144 179.445
R3984 dw_12460_11350.n161 dw_12460_11350.n160 179.445
R3985 dw_12460_11350.n160 dw_12460_11350.n159 179.445
R3986 dw_12460_11350.n159 dw_12460_11350.n7 179.445
R3987 dw_12460_11350.n376 dw_12460_11350.n7 179.445
R3988 dw_12460_11350.n376 dw_12460_11350.n375 179.445
R3989 dw_12460_11350.n375 dw_12460_11350.n374 179.445
R3990 dw_12460_11350.n374 dw_12460_11350.n8 179.445
R3991 dw_12460_11350.n365 dw_12460_11350.n8 179.445
R3992 dw_12460_11350.n365 dw_12460_11350.n364 179.445
R3993 dw_12460_11350.n364 dw_12460_11350.n363 179.445
R3994 dw_12460_11350.n297 dw_12460_11350.n296 179.445
R3995 dw_12460_11350.n298 dw_12460_11350.n297 179.445
R3996 dw_12460_11350.n298 dw_12460_11350.n48 179.445
R3997 dw_12460_11350.n309 dw_12460_11350.n48 179.445
R3998 dw_12460_11350.n310 dw_12460_11350.n309 179.445
R3999 dw_12460_11350.n311 dw_12460_11350.n310 179.445
R4000 dw_12460_11350.n311 dw_12460_11350.n41 179.445
R4001 dw_12460_11350.n322 dw_12460_11350.n41 179.445
R4002 dw_12460_11350.n323 dw_12460_11350.n322 179.445
R4003 dw_12460_11350.n324 dw_12460_11350.n323 179.445
R4004 dw_12460_11350.n324 dw_12460_11350.n34 179.445
R4005 dw_12460_11350.n335 dw_12460_11350.n34 179.445
R4006 dw_12460_11350.n336 dw_12460_11350.n335 179.445
R4007 dw_12460_11350.n337 dw_12460_11350.n336 179.445
R4008 dw_12460_11350.n337 dw_12460_11350.n27 179.445
R4009 dw_12460_11350.n349 dw_12460_11350.n27 179.445
R4010 dw_12460_11350.n350 dw_12460_11350.n349 179.445
R4011 dw_12460_11350.n351 dw_12460_11350.n350 179.445
R4012 dw_12460_11350.n243 dw_12460_11350.n242 179.445
R4013 dw_12460_11350.n244 dw_12460_11350.n243 179.445
R4014 dw_12460_11350.n244 dw_12460_11350.n79 179.445
R4015 dw_12460_11350.n255 dw_12460_11350.n79 179.445
R4016 dw_12460_11350.n256 dw_12460_11350.n255 179.445
R4017 dw_12460_11350.n257 dw_12460_11350.n256 179.445
R4018 dw_12460_11350.n257 dw_12460_11350.n72 179.445
R4019 dw_12460_11350.n268 dw_12460_11350.n72 179.445
R4020 dw_12460_11350.n269 dw_12460_11350.n268 179.445
R4021 dw_12460_11350.n270 dw_12460_11350.n269 179.445
R4022 dw_12460_11350.n270 dw_12460_11350.n65 179.445
R4023 dw_12460_11350.n283 dw_12460_11350.n65 179.445
R4024 dw_12460_11350.n284 dw_12460_11350.n283 179.445
R4025 dw_12460_11350.n285 dw_12460_11350.n284 179.445
R4026 dw_12460_11350.n228 dw_12460_11350.n227 179.445
R4027 dw_12460_11350.n227 dw_12460_11350.n226 179.445
R4028 dw_12460_11350.n226 dw_12460_11350.n94 179.445
R4029 dw_12460_11350.n217 dw_12460_11350.n94 179.445
R4030 dw_12460_11350.n217 dw_12460_11350.n216 179.445
R4031 dw_12460_11350.n216 dw_12460_11350.n215 179.445
R4032 dw_12460_11350.n215 dw_12460_11350.n104 179.445
R4033 dw_12460_11350.n206 dw_12460_11350.n104 179.445
R4034 dw_12460_11350.n206 dw_12460_11350.n205 179.445
R4035 dw_12460_11350.n205 dw_12460_11350.n204 179.445
R4036 dw_12460_11350.n204 dw_12460_11350.n113 179.445
R4037 dw_12460_11350.n195 dw_12460_11350.n113 179.445
R4038 dw_12460_11350.n195 dw_12460_11350.n194 179.445
R4039 dw_12460_11350.n194 dw_12460_11350.n193 179.445
R4040 dw_12460_11350.n193 dw_12460_11350.n122 179.445
R4041 dw_12460_11350.n184 dw_12460_11350.n122 179.445
R4042 dw_12460_11350.n184 dw_12460_11350.n183 179.445
R4043 dw_12460_11350.n183 dw_12460_11350.n182 179.445
R4044 dw_12460_11350.n230 dw_12460_11350.n229 133.172
R4045 dw_12460_11350.n181 dw_12460_11350.n132 133.172
R4046 dw_12460_11350.n295 dw_12460_11350.n56 133.172
R4047 dw_12460_11350.n355 dw_12460_11350.n352 133.172
R4048 dw_12460_11350.n0 dw_12460_11350.t2 105.716
R4049 dw_12460_11350.n233 dw_12460_11350.n87 99.5127
R4050 dw_12460_11350.n241 dw_12460_11350.n87 99.5127
R4051 dw_12460_11350.n241 dw_12460_11350.n85 99.5127
R4052 dw_12460_11350.n245 dw_12460_11350.n85 99.5127
R4053 dw_12460_11350.n245 dw_12460_11350.n80 99.5127
R4054 dw_12460_11350.n254 dw_12460_11350.n80 99.5127
R4055 dw_12460_11350.n254 dw_12460_11350.n78 99.5127
R4056 dw_12460_11350.n258 dw_12460_11350.n78 99.5127
R4057 dw_12460_11350.n258 dw_12460_11350.n73 99.5127
R4058 dw_12460_11350.n267 dw_12460_11350.n73 99.5127
R4059 dw_12460_11350.n267 dw_12460_11350.n71 99.5127
R4060 dw_12460_11350.n271 dw_12460_11350.n71 99.5127
R4061 dw_12460_11350.n271 dw_12460_11350.n66 99.5127
R4062 dw_12460_11350.n282 dw_12460_11350.n66 99.5127
R4063 dw_12460_11350.n282 dw_12460_11350.n62 99.5127
R4064 dw_12460_11350.n286 dw_12460_11350.n62 99.5127
R4065 dw_12460_11350.n287 dw_12460_11350.n286 99.5127
R4066 dw_12460_11350.n229 dw_12460_11350.n92 99.5127
R4067 dw_12460_11350.n225 dw_12460_11350.n92 99.5127
R4068 dw_12460_11350.n225 dw_12460_11350.n95 99.5127
R4069 dw_12460_11350.n218 dw_12460_11350.n95 99.5127
R4070 dw_12460_11350.n218 dw_12460_11350.n103 99.5127
R4071 dw_12460_11350.n214 dw_12460_11350.n103 99.5127
R4072 dw_12460_11350.n214 dw_12460_11350.n105 99.5127
R4073 dw_12460_11350.n207 dw_12460_11350.n105 99.5127
R4074 dw_12460_11350.n207 dw_12460_11350.n112 99.5127
R4075 dw_12460_11350.n203 dw_12460_11350.n112 99.5127
R4076 dw_12460_11350.n203 dw_12460_11350.n114 99.5127
R4077 dw_12460_11350.n196 dw_12460_11350.n114 99.5127
R4078 dw_12460_11350.n196 dw_12460_11350.n121 99.5127
R4079 dw_12460_11350.n192 dw_12460_11350.n121 99.5127
R4080 dw_12460_11350.n192 dw_12460_11350.n123 99.5127
R4081 dw_12460_11350.n185 dw_12460_11350.n123 99.5127
R4082 dw_12460_11350.n185 dw_12460_11350.n130 99.5127
R4083 dw_12460_11350.n181 dw_12460_11350.n130 99.5127
R4084 dw_12460_11350.n142 dw_12460_11350.n139 99.5127
R4085 dw_12460_11350.n173 dw_12460_11350.n142 99.5127
R4086 dw_12460_11350.n173 dw_12460_11350.n143 99.5127
R4087 dw_12460_11350.n169 dw_12460_11350.n143 99.5127
R4088 dw_12460_11350.n169 dw_12460_11350.n145 99.5127
R4089 dw_12460_11350.n162 dw_12460_11350.n145 99.5127
R4090 dw_12460_11350.n162 dw_12460_11350.n152 99.5127
R4091 dw_12460_11350.n158 dw_12460_11350.n152 99.5127
R4092 dw_12460_11350.n158 dw_12460_11350.n5 99.5127
R4093 dw_12460_11350.n377 dw_12460_11350.n5 99.5127
R4094 dw_12460_11350.n377 dw_12460_11350.n6 99.5127
R4095 dw_12460_11350.n373 dw_12460_11350.n6 99.5127
R4096 dw_12460_11350.n373 dw_12460_11350.n9 99.5127
R4097 dw_12460_11350.n366 dw_12460_11350.n9 99.5127
R4098 dw_12460_11350.n366 dw_12460_11350.n16 99.5127
R4099 dw_12460_11350.n362 dw_12460_11350.n16 99.5127
R4100 dw_12460_11350.n362 dw_12460_11350.n18 99.5127
R4101 dw_12460_11350.n295 dw_12460_11350.n54 99.5127
R4102 dw_12460_11350.n299 dw_12460_11350.n54 99.5127
R4103 dw_12460_11350.n299 dw_12460_11350.n49 99.5127
R4104 dw_12460_11350.n308 dw_12460_11350.n49 99.5127
R4105 dw_12460_11350.n308 dw_12460_11350.n47 99.5127
R4106 dw_12460_11350.n312 dw_12460_11350.n47 99.5127
R4107 dw_12460_11350.n312 dw_12460_11350.n42 99.5127
R4108 dw_12460_11350.n321 dw_12460_11350.n42 99.5127
R4109 dw_12460_11350.n321 dw_12460_11350.n40 99.5127
R4110 dw_12460_11350.n325 dw_12460_11350.n40 99.5127
R4111 dw_12460_11350.n325 dw_12460_11350.n35 99.5127
R4112 dw_12460_11350.n334 dw_12460_11350.n35 99.5127
R4113 dw_12460_11350.n334 dw_12460_11350.n33 99.5127
R4114 dw_12460_11350.n338 dw_12460_11350.n33 99.5127
R4115 dw_12460_11350.n338 dw_12460_11350.n28 99.5127
R4116 dw_12460_11350.n348 dw_12460_11350.n28 99.5127
R4117 dw_12460_11350.n348 dw_12460_11350.n26 99.5127
R4118 dw_12460_11350.n352 dw_12460_11350.n26 99.5127
R4119 dw_12460_11350.n232 dw_12460_11350.n231 77.2286
R4120 dw_12460_11350.n141 dw_12460_11350.n140 77.2286
R4121 dw_12460_11350.n289 dw_12460_11350.n56 73.1712
R4122 dw_12460_11350.n355 dw_12460_11350.n24 73.1712
R4123 dw_12460_11350.n288 dw_12460_11350.n61 72.8958
R4124 dw_12460_11350.n354 dw_12460_11350.n353 72.8958
R4125 dw_12460_11350.n172 dw_12460_11350.n131 68.6116
R4126 dw_12460_11350.n363 dw_12460_11350.n17 68.6116
R4127 dw_12460_11350.n242 dw_12460_11350.n86 68.6116
R4128 dw_12460_11350.n285 dw_12460_11350.n55 68.6116
R4129 dw_12460_11350.n0 dw_12460_11350.t1 56.7233
R4130 dw_12460_11350.n61 dw_12460_11350.n55 55.4172
R4131 dw_12460_11350.n354 dw_12460_11350.n17 55.4172
R4132 dw_12460_11350.n231 dw_12460_11350.n86 55.4172
R4133 dw_12460_11350.n141 dw_12460_11350.n131 55.4172
R4134 dw_12460_11350.t0 dw_12460_11350.n385 39.8681
R4135 dw_12460_11350.n288 dw_12460_11350.n287 39.2114
R4136 dw_12460_11350.n289 dw_12460_11350.n288 39.2114
R4137 dw_12460_11350.n353 dw_12460_11350.n24 39.2114
R4138 dw_12460_11350.n353 dw_12460_11350.n18 39.2114
R4139 dw_12460_11350.n232 dw_12460_11350.n230 30.5459
R4140 dw_12460_11350.n233 dw_12460_11350.n232 30.5459
R4141 dw_12460_11350.n140 dw_12460_11350.n132 30.5459
R4142 dw_12460_11350.n140 dw_12460_11350.n139 30.5459
R4143 dw_12460_11350.n93 dw_12460_11350.n91 17.649
R4144 dw_12460_11350.n180 dw_12460_11350.n179 17.649
R4145 dw_12460_11350.n294 dw_12460_11350.n57 17.649
R4146 dw_12460_11350.n356 dw_12460_11350.n25 17.649
R4147 dw_12460_11350.n383 dw_12460_11350.n381 14.2763
R4148 dw_12460_11350.n137 dw_12460_11350.n135 13.1884
R4149 dw_12460_11350.n357 dw_12460_11350.n21 13.1884
R4150 dw_12460_11350.n235 dw_12460_11350.n234 13.1884
R4151 dw_12460_11350.n290 dw_12460_11350.n60 13.1884
R4152 dw_12460_11350.n96 dw_12460_11350.n93 13.1884
R4153 dw_12460_11350.n180 dw_12460_11350.n133 13.1884
R4154 dw_12460_11350.n294 dw_12460_11350.n58 13.1884
R4155 dw_12460_11350.n30 dw_12460_11350.n25 13.1884
R4156 dw_12460_11350.n175 dw_12460_11350.n174 12.4126
R4157 dw_12460_11350.n361 dw_12460_11350.n360 12.4126
R4158 dw_12460_11350.n240 dw_12460_11350.n88 12.4126
R4159 dw_12460_11350.n64 dw_12460_11350.n63 12.4126
R4160 dw_12460_11350.n224 dw_12460_11350.n97 12.4126
R4161 dw_12460_11350.n186 dw_12460_11350.n129 12.4126
R4162 dw_12460_11350.n300 dw_12460_11350.n53 12.4126
R4163 dw_12460_11350.n347 dw_12460_11350.n346 12.4126
R4164 dw_12460_11350.n146 dw_12460_11350.n138 11.6369
R4165 dw_12460_11350.n20 dw_12460_11350.n19 11.6369
R4166 dw_12460_11350.n239 dw_12460_11350.n89 11.6369
R4167 dw_12460_11350.n277 dw_12460_11350.n68 11.6369
R4168 dw_12460_11350.n223 dw_12460_11350.n98 11.6369
R4169 dw_12460_11350.n187 dw_12460_11350.n126 11.6369
R4170 dw_12460_11350.n302 dw_12460_11350.n301 11.6369
R4171 dw_12460_11350.n340 dw_12460_11350.n29 11.6369
R4172 dw_12460_11350.n383 dw_12460_11350.n382 11.6017
R4173 dw_12460_11350.n179 dw_12460_11350.n135 11.249
R4174 dw_12460_11350.n357 dw_12460_11350.n356 11.249
R4175 dw_12460_11350.n235 dw_12460_11350.n91 11.249
R4176 dw_12460_11350.n290 dw_12460_11350.n57 11.249
R4177 dw_12460_11350.n168 dw_12460_11350.n147 10.8611
R4178 dw_12460_11350.n367 dw_12460_11350.n15 10.8611
R4179 dw_12460_11350.n246 dw_12460_11350.n84 10.8611
R4180 dw_12460_11350.n281 dw_12460_11350.n280 10.8611
R4181 dw_12460_11350.n220 dw_12460_11350.n219 10.8611
R4182 dw_12460_11350.n191 dw_12460_11350.n190 10.8611
R4183 dw_12460_11350.n307 dw_12460_11350.n50 10.8611
R4184 dw_12460_11350.n341 dw_12460_11350.n339 10.8611
R4185 dw_12460_11350.n167 dw_12460_11350.n148 10.0853
R4186 dw_12460_11350.n368 dw_12460_11350.n12 10.0853
R4187 dw_12460_11350.n248 dw_12460_11350.n247 10.0853
R4188 dw_12460_11350.n273 dw_12460_11350.n67 10.0853
R4189 dw_12460_11350.n106 dw_12460_11350.n102 10.0853
R4190 dw_12460_11350.n125 dw_12460_11350.n124 10.0853
R4191 dw_12460_11350.n306 dw_12460_11350.n51 10.0853
R4192 dw_12460_11350.n37 dw_12460_11350.n32 10.0853
R4193 dw_12460_11350.n164 dw_12460_11350.n163 9.30959
R4194 dw_12460_11350.n372 dw_12460_11350.n371 9.30959
R4195 dw_12460_11350.n253 dw_12460_11350.n81 9.30959
R4196 dw_12460_11350.n274 dw_12460_11350.n272 9.30959
R4197 dw_12460_11350.n213 dw_12460_11350.n107 9.30959
R4198 dw_12460_11350.n197 dw_12460_11350.n120 9.30959
R4199 dw_12460_11350.n313 dw_12460_11350.n46 9.30959
R4200 dw_12460_11350.n333 dw_12460_11350.n332 9.30959
R4201 dw_12460_11350.n155 dw_12460_11350.n154 9.3005
R4202 dw_12460_11350.n151 dw_12460_11350.n150 9.3005
R4203 dw_12460_11350.n165 dw_12460_11350.n164 9.3005
R4204 dw_12460_11350.n167 dw_12460_11350.n166 9.3005
R4205 dw_12460_11350.n149 dw_12460_11350.n147 9.3005
R4206 dw_12460_11350.n138 dw_12460_11350.n136 9.3005
R4207 dw_12460_11350.n176 dw_12460_11350.n175 9.3005
R4208 dw_12460_11350.n177 dw_12460_11350.n135 9.3005
R4209 dw_12460_11350.n236 dw_12460_11350.n235 9.3005
R4210 dw_12460_11350.n237 dw_12460_11350.n88 9.3005
R4211 dw_12460_11350.n239 dw_12460_11350.n238 9.3005
R4212 dw_12460_11350.n84 dw_12460_11350.n83 9.3005
R4213 dw_12460_11350.n249 dw_12460_11350.n248 9.3005
R4214 dw_12460_11350.n250 dw_12460_11350.n81 9.3005
R4215 dw_12460_11350.n252 dw_12460_11350.n251 9.3005
R4216 dw_12460_11350.n77 dw_12460_11350.n76 9.3005
R4217 dw_12460_11350.n262 dw_12460_11350.n261 9.3005
R4218 dw_12460_11350.n263 dw_12460_11350.n74 9.3005
R4219 dw_12460_11350.n265 dw_12460_11350.n264 9.3005
R4220 dw_12460_11350.n70 dw_12460_11350.n69 9.3005
R4221 dw_12460_11350.n275 dw_12460_11350.n274 9.3005
R4222 dw_12460_11350.n276 dw_12460_11350.n67 9.3005
R4223 dw_12460_11350.n280 dw_12460_11350.n279 9.3005
R4224 dw_12460_11350.n278 dw_12460_11350.n277 9.3005
R4225 dw_12460_11350.n63 dw_12460_11350.n59 9.3005
R4226 dw_12460_11350.n291 dw_12460_11350.n290 9.3005
R4227 dw_12460_11350.n91 dw_12460_11350.n90 9.3005
R4228 dw_12460_11350.n99 dw_12460_11350.n93 9.3005
R4229 dw_12460_11350.n100 dw_12460_11350.n97 9.3005
R4230 dw_12460_11350.n223 dw_12460_11350.n222 9.3005
R4231 dw_12460_11350.n221 dw_12460_11350.n220 9.3005
R4232 dw_12460_11350.n102 dw_12460_11350.n101 9.3005
R4233 dw_12460_11350.n109 dw_12460_11350.n107 9.3005
R4234 dw_12460_11350.n212 dw_12460_11350.n211 9.3005
R4235 dw_12460_11350.n210 dw_12460_11350.n209 9.3005
R4236 dw_12460_11350.n111 dw_12460_11350.n110 9.3005
R4237 dw_12460_11350.n118 dw_12460_11350.n116 9.3005
R4238 dw_12460_11350.n201 dw_12460_11350.n200 9.3005
R4239 dw_12460_11350.n199 dw_12460_11350.n198 9.3005
R4240 dw_12460_11350.n120 dw_12460_11350.n119 9.3005
R4241 dw_12460_11350.n127 dw_12460_11350.n125 9.3005
R4242 dw_12460_11350.n190 dw_12460_11350.n189 9.3005
R4243 dw_12460_11350.n188 dw_12460_11350.n187 9.3005
R4244 dw_12460_11350.n129 dw_12460_11350.n128 9.3005
R4245 dw_12460_11350.n180 dw_12460_11350.n134 9.3005
R4246 dw_12460_11350.n179 dw_12460_11350.n178 9.3005
R4247 dw_12460_11350.n294 dw_12460_11350.n293 9.3005
R4248 dw_12460_11350.n53 dw_12460_11350.n52 9.3005
R4249 dw_12460_11350.n303 dw_12460_11350.n302 9.3005
R4250 dw_12460_11350.n304 dw_12460_11350.n50 9.3005
R4251 dw_12460_11350.n306 dw_12460_11350.n305 9.3005
R4252 dw_12460_11350.n46 dw_12460_11350.n45 9.3005
R4253 dw_12460_11350.n316 dw_12460_11350.n315 9.3005
R4254 dw_12460_11350.n317 dw_12460_11350.n43 9.3005
R4255 dw_12460_11350.n319 dw_12460_11350.n318 9.3005
R4256 dw_12460_11350.n39 dw_12460_11350.n38 9.3005
R4257 dw_12460_11350.n329 dw_12460_11350.n328 9.3005
R4258 dw_12460_11350.n330 dw_12460_11350.n36 9.3005
R4259 dw_12460_11350.n332 dw_12460_11350.n331 9.3005
R4260 dw_12460_11350.n32 dw_12460_11350.n31 9.3005
R4261 dw_12460_11350.n342 dw_12460_11350.n341 9.3005
R4262 dw_12460_11350.n343 dw_12460_11350.n29 9.3005
R4263 dw_12460_11350.n346 dw_12460_11350.n345 9.3005
R4264 dw_12460_11350.n344 dw_12460_11350.n25 9.3005
R4265 dw_12460_11350.n356 dw_12460_11350.n23 9.3005
R4266 dw_12460_11350.n292 dw_12460_11350.n57 9.3005
R4267 dw_12460_11350.n358 dw_12460_11350.n357 9.3005
R4268 dw_12460_11350.n4 dw_12460_11350.n2 9.3005
R4269 dw_12460_11350.n13 dw_12460_11350.n11 9.3005
R4270 dw_12460_11350.n371 dw_12460_11350.n370 9.3005
R4271 dw_12460_11350.n369 dw_12460_11350.n368 9.3005
R4272 dw_12460_11350.n15 dw_12460_11350.n14 9.3005
R4273 dw_12460_11350.n22 dw_12460_11350.n20 9.3005
R4274 dw_12460_11350.n360 dw_12460_11350.n359 9.3005
R4275 dw_12460_11350.n156 dw_12460_11350.n1 9.3005
R4276 dw_12460_11350.n380 dw_12460_11350.n379 9.3005
R4277 dw_12460_11350.n153 dw_12460_11350.n151 8.53383
R4278 dw_12460_11350.n11 dw_12460_11350.n10 8.53383
R4279 dw_12460_11350.n252 dw_12460_11350.n82 8.53383
R4280 dw_12460_11350.n75 dw_12460_11350.n70 8.53383
R4281 dw_12460_11350.n212 dw_12460_11350.n108 8.53383
R4282 dw_12460_11350.n198 dw_12460_11350.n117 8.53383
R4283 dw_12460_11350.n315 dw_12460_11350.n314 8.53383
R4284 dw_12460_11350.n327 dw_12460_11350.n36 8.53383
R4285 dw_12460_11350.n157 dw_12460_11350.n155 7.75808
R4286 dw_12460_11350.n378 dw_12460_11350.n4 7.75808
R4287 dw_12460_11350.n259 dw_12460_11350.n77 7.75808
R4288 dw_12460_11350.n266 dw_12460_11350.n265 7.75808
R4289 dw_12460_11350.n209 dw_12460_11350.n208 7.75808
R4290 dw_12460_11350.n202 dw_12460_11350.n201 7.75808
R4291 dw_12460_11350.n320 dw_12460_11350.n43 7.75808
R4292 dw_12460_11350.n328 dw_12460_11350.n326 7.75808
R4293 dw_12460_11350.n156 dw_12460_11350.n3 6.98232
R4294 dw_12460_11350.n379 dw_12460_11350.n3 6.98232
R4295 dw_12460_11350.n261 dw_12460_11350.n260 6.98232
R4296 dw_12460_11350.n260 dw_12460_11350.n74 6.98232
R4297 dw_12460_11350.n115 dw_12460_11350.n111 6.98232
R4298 dw_12460_11350.n116 dw_12460_11350.n115 6.98232
R4299 dw_12460_11350.n319 dw_12460_11350.n44 6.98232
R4300 dw_12460_11350.n44 dw_12460_11350.n39 6.98232
R4301 dw_12460_11350.n385 dw_12460_11350.n384 6.8205
R4302 dw_12460_11350.n157 dw_12460_11350.n156 6.20656
R4303 dw_12460_11350.n379 dw_12460_11350.n378 6.20656
R4304 dw_12460_11350.n261 dw_12460_11350.n259 6.20656
R4305 dw_12460_11350.n266 dw_12460_11350.n74 6.20656
R4306 dw_12460_11350.n208 dw_12460_11350.n111 6.20656
R4307 dw_12460_11350.n202 dw_12460_11350.n116 6.20656
R4308 dw_12460_11350.n320 dw_12460_11350.n319 6.20656
R4309 dw_12460_11350.n326 dw_12460_11350.n39 6.20656
R4310 dw_12460_11350.n384 dw_12460_11350.t3 5.59793
R4311 dw_12460_11350.n155 dw_12460_11350.n153 5.4308
R4312 dw_12460_11350.n10 dw_12460_11350.n4 5.4308
R4313 dw_12460_11350.n82 dw_12460_11350.n77 5.4308
R4314 dw_12460_11350.n265 dw_12460_11350.n75 5.4308
R4315 dw_12460_11350.n209 dw_12460_11350.n108 5.4308
R4316 dw_12460_11350.n201 dw_12460_11350.n117 5.4308
R4317 dw_12460_11350.n314 dw_12460_11350.n43 5.4308
R4318 dw_12460_11350.n328 dw_12460_11350.n327 5.4308
R4319 dw_12460_11350.n163 dw_12460_11350.n151 4.65505
R4320 dw_12460_11350.n372 dw_12460_11350.n11 4.65505
R4321 dw_12460_11350.n253 dw_12460_11350.n252 4.65505
R4322 dw_12460_11350.n272 dw_12460_11350.n70 4.65505
R4323 dw_12460_11350.n213 dw_12460_11350.n212 4.65505
R4324 dw_12460_11350.n198 dw_12460_11350.n197 4.65505
R4325 dw_12460_11350.n315 dw_12460_11350.n313 4.65505
R4326 dw_12460_11350.n333 dw_12460_11350.n36 4.65505
R4327 dw_12460_11350.n164 dw_12460_11350.n148 3.87929
R4328 dw_12460_11350.n371 dw_12460_11350.n12 3.87929
R4329 dw_12460_11350.n247 dw_12460_11350.n81 3.87929
R4330 dw_12460_11350.n274 dw_12460_11350.n273 3.87929
R4331 dw_12460_11350.n107 dw_12460_11350.n106 3.87929
R4332 dw_12460_11350.n124 dw_12460_11350.n120 3.87929
R4333 dw_12460_11350.n51 dw_12460_11350.n46 3.87929
R4334 dw_12460_11350.n332 dw_12460_11350.n37 3.87929
R4335 dw_12460_11350.n168 dw_12460_11350.n167 3.10353
R4336 dw_12460_11350.n368 dw_12460_11350.n367 3.10353
R4337 dw_12460_11350.n248 dw_12460_11350.n246 3.10353
R4338 dw_12460_11350.n281 dw_12460_11350.n67 3.10353
R4339 dw_12460_11350.n219 dw_12460_11350.n102 3.10353
R4340 dw_12460_11350.n191 dw_12460_11350.n125 3.10353
R4341 dw_12460_11350.n307 dw_12460_11350.n306 3.10353
R4342 dw_12460_11350.n339 dw_12460_11350.n32 3.10353
R4343 dw_12460_11350.n384 dw_12460_11350.n383 2.73825
R4344 dw_12460_11350.n147 dw_12460_11350.n146 2.32777
R4345 dw_12460_11350.n19 dw_12460_11350.n15 2.32777
R4346 dw_12460_11350.n89 dw_12460_11350.n84 2.32777
R4347 dw_12460_11350.n280 dw_12460_11350.n68 2.32777
R4348 dw_12460_11350.n220 dw_12460_11350.n98 2.32777
R4349 dw_12460_11350.n190 dw_12460_11350.n126 2.32777
R4350 dw_12460_11350.n301 dw_12460_11350.n50 2.32777
R4351 dw_12460_11350.n341 dw_12460_11350.n340 2.32777
R4352 dw_12460_11350.n385 dw_12460_11350.n0 1.99425
R4353 dw_12460_11350.n174 dw_12460_11350.n138 1.55202
R4354 dw_12460_11350.n361 dw_12460_11350.n20 1.55202
R4355 dw_12460_11350.n240 dw_12460_11350.n239 1.55202
R4356 dw_12460_11350.n277 dw_12460_11350.n64 1.55202
R4357 dw_12460_11350.n224 dw_12460_11350.n223 1.55202
R4358 dw_12460_11350.n187 dw_12460_11350.n186 1.55202
R4359 dw_12460_11350.n302 dw_12460_11350.n300 1.55202
R4360 dw_12460_11350.n347 dw_12460_11350.n29 1.55202
R4361 dw_12460_11350.n175 dw_12460_11350.n137 0.776258
R4362 dw_12460_11350.n360 dw_12460_11350.n21 0.776258
R4363 dw_12460_11350.n234 dw_12460_11350.n88 0.776258
R4364 dw_12460_11350.n63 dw_12460_11350.n60 0.776258
R4365 dw_12460_11350.n97 dw_12460_11350.n96 0.776258
R4366 dw_12460_11350.n133 dw_12460_11350.n129 0.776258
R4367 dw_12460_11350.n58 dw_12460_11350.n53 0.776258
R4368 dw_12460_11350.n346 dw_12460_11350.n30 0.776258
R4369 dw_12460_11350.n99 dw_12460_11350.n90 0.196621
R4370 dw_12460_11350.n178 dw_12460_11350.n134 0.196621
R4371 dw_12460_11350.n293 dw_12460_11350.n292 0.196621
R4372 dw_12460_11350.n344 dw_12460_11350.n23 0.196621
R4373 dw_12460_11350.n177 dw_12460_11350.n176 0.155672
R4374 dw_12460_11350.n176 dw_12460_11350.n136 0.155672
R4375 dw_12460_11350.n149 dw_12460_11350.n136 0.155672
R4376 dw_12460_11350.n166 dw_12460_11350.n149 0.155672
R4377 dw_12460_11350.n166 dw_12460_11350.n165 0.155672
R4378 dw_12460_11350.n165 dw_12460_11350.n150 0.155672
R4379 dw_12460_11350.n154 dw_12460_11350.n150 0.155672
R4380 dw_12460_11350.n237 dw_12460_11350.n236 0.155672
R4381 dw_12460_11350.n238 dw_12460_11350.n237 0.155672
R4382 dw_12460_11350.n238 dw_12460_11350.n83 0.155672
R4383 dw_12460_11350.n249 dw_12460_11350.n83 0.155672
R4384 dw_12460_11350.n250 dw_12460_11350.n249 0.155672
R4385 dw_12460_11350.n251 dw_12460_11350.n250 0.155672
R4386 dw_12460_11350.n251 dw_12460_11350.n76 0.155672
R4387 dw_12460_11350.n262 dw_12460_11350.n76 0.155672
R4388 dw_12460_11350.n263 dw_12460_11350.n262 0.155672
R4389 dw_12460_11350.n264 dw_12460_11350.n263 0.155672
R4390 dw_12460_11350.n264 dw_12460_11350.n69 0.155672
R4391 dw_12460_11350.n275 dw_12460_11350.n69 0.155672
R4392 dw_12460_11350.n276 dw_12460_11350.n275 0.155672
R4393 dw_12460_11350.n279 dw_12460_11350.n276 0.155672
R4394 dw_12460_11350.n279 dw_12460_11350.n278 0.155672
R4395 dw_12460_11350.n278 dw_12460_11350.n59 0.155672
R4396 dw_12460_11350.n291 dw_12460_11350.n59 0.155672
R4397 dw_12460_11350.n100 dw_12460_11350.n99 0.155672
R4398 dw_12460_11350.n222 dw_12460_11350.n100 0.155672
R4399 dw_12460_11350.n222 dw_12460_11350.n221 0.155672
R4400 dw_12460_11350.n221 dw_12460_11350.n101 0.155672
R4401 dw_12460_11350.n109 dw_12460_11350.n101 0.155672
R4402 dw_12460_11350.n211 dw_12460_11350.n109 0.155672
R4403 dw_12460_11350.n211 dw_12460_11350.n210 0.155672
R4404 dw_12460_11350.n210 dw_12460_11350.n110 0.155672
R4405 dw_12460_11350.n118 dw_12460_11350.n110 0.155672
R4406 dw_12460_11350.n200 dw_12460_11350.n118 0.155672
R4407 dw_12460_11350.n200 dw_12460_11350.n199 0.155672
R4408 dw_12460_11350.n199 dw_12460_11350.n119 0.155672
R4409 dw_12460_11350.n127 dw_12460_11350.n119 0.155672
R4410 dw_12460_11350.n189 dw_12460_11350.n127 0.155672
R4411 dw_12460_11350.n189 dw_12460_11350.n188 0.155672
R4412 dw_12460_11350.n188 dw_12460_11350.n128 0.155672
R4413 dw_12460_11350.n134 dw_12460_11350.n128 0.155672
R4414 dw_12460_11350.n293 dw_12460_11350.n52 0.155672
R4415 dw_12460_11350.n303 dw_12460_11350.n52 0.155672
R4416 dw_12460_11350.n304 dw_12460_11350.n303 0.155672
R4417 dw_12460_11350.n305 dw_12460_11350.n304 0.155672
R4418 dw_12460_11350.n305 dw_12460_11350.n45 0.155672
R4419 dw_12460_11350.n316 dw_12460_11350.n45 0.155672
R4420 dw_12460_11350.n317 dw_12460_11350.n316 0.155672
R4421 dw_12460_11350.n318 dw_12460_11350.n317 0.155672
R4422 dw_12460_11350.n318 dw_12460_11350.n38 0.155672
R4423 dw_12460_11350.n329 dw_12460_11350.n38 0.155672
R4424 dw_12460_11350.n330 dw_12460_11350.n329 0.155672
R4425 dw_12460_11350.n331 dw_12460_11350.n330 0.155672
R4426 dw_12460_11350.n331 dw_12460_11350.n31 0.155672
R4427 dw_12460_11350.n342 dw_12460_11350.n31 0.155672
R4428 dw_12460_11350.n343 dw_12460_11350.n342 0.155672
R4429 dw_12460_11350.n345 dw_12460_11350.n343 0.155672
R4430 dw_12460_11350.n345 dw_12460_11350.n344 0.155672
R4431 dw_12460_11350.n13 dw_12460_11350.n2 0.155672
R4432 dw_12460_11350.n370 dw_12460_11350.n13 0.155672
R4433 dw_12460_11350.n370 dw_12460_11350.n369 0.155672
R4434 dw_12460_11350.n369 dw_12460_11350.n14 0.155672
R4435 dw_12460_11350.n22 dw_12460_11350.n14 0.155672
R4436 dw_12460_11350.n359 dw_12460_11350.n22 0.155672
R4437 dw_12460_11350.n359 dw_12460_11350.n358 0.155672
R4438 dw_12460_11350.n154 dw_12460_11350.n1 0.154652
R4439 dw_12460_11350.n380 dw_12460_11350.n2 0.154652
R4440 dw_12460_11350.n178 dw_12460_11350.n177 0.134121
R4441 dw_12460_11350.n236 dw_12460_11350.n90 0.134121
R4442 dw_12460_11350.n292 dw_12460_11350.n291 0.134121
R4443 dw_12460_11350.n358 dw_12460_11350.n23 0.134121
R4444 dw_12460_11350.n381 dw_12460_11350.n1 0.0597105
R4445 dw_12460_11350.n381 dw_12460_11350.n380 0.0597105
R4446 dw_12460_11350# dw_12460_11350.t1 0.0005
R4447 nv.n383 nv.t4 375.515
R4448 nv.n383 nv.t5 374.265
R4449 nv.n236 nv.n234 185
R4450 nv.n235 nv.n88 185
R4451 nv.n232 nv.n88 185
R4452 nv.n242 nv.n241 185
R4453 nv.n243 nv.n242 185
R4454 nv.n90 nv.n86 185
R4455 nv.n244 nv.n86 185
R4456 nv.n247 nv.n246 185
R4457 nv.n246 nv.n245 185
R4458 nv.n248 nv.n81 185
R4459 nv.n81 nv.n80 185
R4460 nv.n255 nv.n254 185
R4461 nv.n256 nv.n255 185
R4462 nv.n83 nv.n79 185
R4463 nv.n257 nv.n79 185
R4464 nv.n260 nv.n259 185
R4465 nv.n259 nv.n258 185
R4466 nv.n261 nv.n74 185
R4467 nv.n74 nv.n73 185
R4468 nv.n268 nv.n267 185
R4469 nv.n269 nv.n268 185
R4470 nv.n76 nv.n72 185
R4471 nv.n270 nv.n72 185
R4472 nv.n273 nv.n272 185
R4473 nv.n272 nv.n271 185
R4474 nv.n274 nv.n67 185
R4475 nv.n67 nv.n66 185
R4476 nv.n283 nv.n282 185
R4477 nv.n284 nv.n283 185
R4478 nv.n69 nv.n63 185
R4479 nv.n285 nv.n63 185
R4480 nv.n287 nv.n65 185
R4481 nv.n287 nv.n286 185
R4482 nv.n288 nv.n61 185
R4483 nv.n291 nv.n290 185
R4484 nv.n180 nv.n133 185
R4485 nv.n182 nv.n181 185
R4486 nv.n183 nv.n182 185
R4487 nv.n134 nv.n131 185
R4488 nv.n184 nv.n131 185
R4489 nv.n187 nv.n186 185
R4490 nv.n186 nv.n185 185
R4491 nv.n127 nv.n124 185
R4492 nv.n124 nv.n123 185
R4493 nv.n193 nv.n192 185
R4494 nv.n194 nv.n193 185
R4495 nv.n125 nv.n122 185
R4496 nv.n195 nv.n122 185
R4497 nv.n198 nv.n197 185
R4498 nv.n197 nv.n196 185
R4499 nv.n118 nv.n115 185
R4500 nv.n115 nv.n114 185
R4501 nv.n204 nv.n203 185
R4502 nv.n205 nv.n204 185
R4503 nv.n116 nv.n113 185
R4504 nv.n206 nv.n113 185
R4505 nv.n209 nv.n208 185
R4506 nv.n208 nv.n207 185
R4507 nv.n109 nv.n106 185
R4508 nv.n106 nv.n105 185
R4509 nv.n215 nv.n214 185
R4510 nv.n216 nv.n215 185
R4511 nv.n107 nv.n104 185
R4512 nv.n217 nv.n104 185
R4513 nv.n220 nv.n219 185
R4514 nv.n219 nv.n218 185
R4515 nv.n99 nv.n96 185
R4516 nv.n96 nv.n95 185
R4517 nv.n226 nv.n225 185
R4518 nv.n227 nv.n226 185
R4519 nv.n97 nv.n93 185
R4520 nv.n228 nv.n93 185
R4521 nv.n230 nv.n94 185
R4522 nv.n230 nv.n229 185
R4523 nv.n231 nv.n92 185
R4524 nv.n358 nv.n25 185
R4525 nv.n22 nv.n19 185
R4526 nv.n363 nv.n362 185
R4527 nv.n364 nv.n363 185
R4528 nv.n20 nv.n17 185
R4529 nv.n365 nv.n17 185
R4530 nv.n368 nv.n367 185
R4531 nv.n367 nv.n366 185
R4532 nv.n13 nv.n10 185
R4533 nv.n10 nv.n9 185
R4534 nv.n374 nv.n373 185
R4535 nv.n375 nv.n374 185
R4536 nv.n11 nv.n7 185
R4537 nv.n376 nv.n7 185
R4538 nv.n379 nv.n378 185
R4539 nv.n378 nv.n377 185
R4540 nv.n6 nv.n4 185
R4541 nv.n8 nv.n6 185
R4542 nv.n159 nv.n158 185
R4543 nv.n160 nv.n159 185
R4544 nv.n154 nv.n153 185
R4545 nv.n161 nv.n153 185
R4546 nv.n164 nv.n163 185
R4547 nv.n163 nv.n162 185
R4548 nv.n149 nv.n146 185
R4549 nv.n146 nv.n145 185
R4550 nv.n170 nv.n169 185
R4551 nv.n171 nv.n170 185
R4552 nv.n147 nv.n144 185
R4553 nv.n172 nv.n144 185
R4554 nv.n175 nv.n174 185
R4555 nv.n174 nv.n173 185
R4556 nv.n143 nv.n138 185
R4557 nv.n143 nv.n142 185
R4558 nv.n140 nv.n136 185
R4559 nv.n357 nv.n356 185
R4560 nv.n356 nv.n355 185
R4561 nv.n353 nv.n26 185
R4562 nv.n353 nv.n352 185
R4563 nv.n31 nv.n27 185
R4564 nv.n351 nv.n27 185
R4565 nv.n349 nv.n348 185
R4566 nv.n350 nv.n349 185
R4567 nv.n341 nv.n29 185
R4568 nv.n29 nv.n28 185
R4569 nv.n340 nv.n339 185
R4570 nv.n339 nv.n338 185
R4571 nv.n38 nv.n34 185
R4572 nv.n337 nv.n34 185
R4573 nv.n335 nv.n334 185
R4574 nv.n336 nv.n335 185
R4575 nv.n328 nv.n36 185
R4576 nv.n36 nv.n35 185
R4577 nv.n327 nv.n326 185
R4578 nv.n326 nv.n325 185
R4579 nv.n45 nv.n41 185
R4580 nv.n324 nv.n41 185
R4581 nv.n322 nv.n321 185
R4582 nv.n323 nv.n322 185
R4583 nv.n315 nv.n43 185
R4584 nv.n43 nv.n42 185
R4585 nv.n314 nv.n313 185
R4586 nv.n313 nv.n312 185
R4587 nv.n52 nv.n48 185
R4588 nv.n311 nv.n48 185
R4589 nv.n309 nv.n308 185
R4590 nv.n310 nv.n309 185
R4591 nv.n302 nv.n50 185
R4592 nv.n50 nv.n49 185
R4593 nv.n301 nv.n300 185
R4594 nv.n300 nv.n299 185
R4595 nv.n59 nv.n55 185
R4596 nv.n298 nv.n55 185
R4597 nv.n296 nv.n295 185
R4598 nv.n297 nv.n296 185
R4599 nv.n58 nv.n57 185
R4600 nv.n62 nv.n57 185
R4601 nv.n297 nv.n56 184.722
R4602 nv.n352 nv.n18 184.722
R4603 nv.n229 nv.n87 184.722
R4604 nv.n183 nv.n132 184.722
R4605 nv.n173 nv.n172 179.445
R4606 nv.n172 nv.n171 179.445
R4607 nv.n171 nv.n145 179.445
R4608 nv.n162 nv.n145 179.445
R4609 nv.n162 nv.n161 179.445
R4610 nv.n161 nv.n160 179.445
R4611 nv.n160 nv.n8 179.445
R4612 nv.n377 nv.n8 179.445
R4613 nv.n377 nv.n376 179.445
R4614 nv.n376 nv.n375 179.445
R4615 nv.n375 nv.n9 179.445
R4616 nv.n366 nv.n9 179.445
R4617 nv.n366 nv.n365 179.445
R4618 nv.n365 nv.n364 179.445
R4619 nv.n298 nv.n297 179.445
R4620 nv.n299 nv.n298 179.445
R4621 nv.n299 nv.n49 179.445
R4622 nv.n310 nv.n49 179.445
R4623 nv.n311 nv.n310 179.445
R4624 nv.n312 nv.n311 179.445
R4625 nv.n312 nv.n42 179.445
R4626 nv.n323 nv.n42 179.445
R4627 nv.n324 nv.n323 179.445
R4628 nv.n325 nv.n324 179.445
R4629 nv.n325 nv.n35 179.445
R4630 nv.n336 nv.n35 179.445
R4631 nv.n337 nv.n336 179.445
R4632 nv.n338 nv.n337 179.445
R4633 nv.n338 nv.n28 179.445
R4634 nv.n350 nv.n28 179.445
R4635 nv.n351 nv.n350 179.445
R4636 nv.n352 nv.n351 179.445
R4637 nv.n244 nv.n243 179.445
R4638 nv.n245 nv.n244 179.445
R4639 nv.n245 nv.n80 179.445
R4640 nv.n256 nv.n80 179.445
R4641 nv.n257 nv.n256 179.445
R4642 nv.n258 nv.n257 179.445
R4643 nv.n258 nv.n73 179.445
R4644 nv.n269 nv.n73 179.445
R4645 nv.n270 nv.n269 179.445
R4646 nv.n271 nv.n270 179.445
R4647 nv.n271 nv.n66 179.445
R4648 nv.n284 nv.n66 179.445
R4649 nv.n285 nv.n284 179.445
R4650 nv.n286 nv.n285 179.445
R4651 nv.n229 nv.n228 179.445
R4652 nv.n228 nv.n227 179.445
R4653 nv.n227 nv.n95 179.445
R4654 nv.n218 nv.n95 179.445
R4655 nv.n218 nv.n217 179.445
R4656 nv.n217 nv.n216 179.445
R4657 nv.n216 nv.n105 179.445
R4658 nv.n207 nv.n105 179.445
R4659 nv.n207 nv.n206 179.445
R4660 nv.n206 nv.n205 179.445
R4661 nv.n205 nv.n114 179.445
R4662 nv.n196 nv.n114 179.445
R4663 nv.n196 nv.n195 179.445
R4664 nv.n195 nv.n194 179.445
R4665 nv.n194 nv.n123 179.445
R4666 nv.n185 nv.n123 179.445
R4667 nv.n185 nv.n184 179.445
R4668 nv.n184 nv.n183 179.445
R4669 nv.n231 nv.n230 133.172
R4670 nv.n182 nv.n133 133.172
R4671 nv.n296 nv.n57 133.172
R4672 nv.n356 nv.n353 133.172
R4673 nv.n234 nv.n88 99.5127
R4674 nv.n242 nv.n88 99.5127
R4675 nv.n242 nv.n86 99.5127
R4676 nv.n246 nv.n86 99.5127
R4677 nv.n246 nv.n81 99.5127
R4678 nv.n255 nv.n81 99.5127
R4679 nv.n255 nv.n79 99.5127
R4680 nv.n259 nv.n79 99.5127
R4681 nv.n259 nv.n74 99.5127
R4682 nv.n268 nv.n74 99.5127
R4683 nv.n268 nv.n72 99.5127
R4684 nv.n272 nv.n72 99.5127
R4685 nv.n272 nv.n67 99.5127
R4686 nv.n283 nv.n67 99.5127
R4687 nv.n283 nv.n63 99.5127
R4688 nv.n287 nv.n63 99.5127
R4689 nv.n288 nv.n287 99.5127
R4690 nv.n230 nv.n93 99.5127
R4691 nv.n226 nv.n93 99.5127
R4692 nv.n226 nv.n96 99.5127
R4693 nv.n219 nv.n96 99.5127
R4694 nv.n219 nv.n104 99.5127
R4695 nv.n215 nv.n104 99.5127
R4696 nv.n215 nv.n106 99.5127
R4697 nv.n208 nv.n106 99.5127
R4698 nv.n208 nv.n113 99.5127
R4699 nv.n204 nv.n113 99.5127
R4700 nv.n204 nv.n115 99.5127
R4701 nv.n197 nv.n115 99.5127
R4702 nv.n197 nv.n122 99.5127
R4703 nv.n193 nv.n122 99.5127
R4704 nv.n193 nv.n124 99.5127
R4705 nv.n186 nv.n124 99.5127
R4706 nv.n186 nv.n131 99.5127
R4707 nv.n182 nv.n131 99.5127
R4708 nv.n143 nv.n140 99.5127
R4709 nv.n174 nv.n143 99.5127
R4710 nv.n174 nv.n144 99.5127
R4711 nv.n170 nv.n144 99.5127
R4712 nv.n170 nv.n146 99.5127
R4713 nv.n163 nv.n146 99.5127
R4714 nv.n163 nv.n153 99.5127
R4715 nv.n159 nv.n153 99.5127
R4716 nv.n159 nv.n6 99.5127
R4717 nv.n378 nv.n6 99.5127
R4718 nv.n378 nv.n7 99.5127
R4719 nv.n374 nv.n7 99.5127
R4720 nv.n374 nv.n10 99.5127
R4721 nv.n367 nv.n10 99.5127
R4722 nv.n367 nv.n17 99.5127
R4723 nv.n363 nv.n17 99.5127
R4724 nv.n363 nv.n19 99.5127
R4725 nv.n296 nv.n55 99.5127
R4726 nv.n300 nv.n55 99.5127
R4727 nv.n300 nv.n50 99.5127
R4728 nv.n309 nv.n50 99.5127
R4729 nv.n309 nv.n48 99.5127
R4730 nv.n313 nv.n48 99.5127
R4731 nv.n313 nv.n43 99.5127
R4732 nv.n322 nv.n43 99.5127
R4733 nv.n322 nv.n41 99.5127
R4734 nv.n326 nv.n41 99.5127
R4735 nv.n326 nv.n36 99.5127
R4736 nv.n335 nv.n36 99.5127
R4737 nv.n335 nv.n34 99.5127
R4738 nv.n339 nv.n34 99.5127
R4739 nv.n339 nv.n29 99.5127
R4740 nv.n349 nv.n29 99.5127
R4741 nv.n349 nv.n27 99.5127
R4742 nv.n353 nv.n27 99.5127
R4743 nv.n233 nv.n232 77.2286
R4744 nv.n142 nv.n141 77.2286
R4745 nv.n290 nv.n57 73.1712
R4746 nv.n356 nv.n25 73.1712
R4747 nv.n289 nv.n62 72.8958
R4748 nv.n355 nv.n354 72.8958
R4749 nv.n173 nv.n132 68.6116
R4750 nv.n364 nv.n18 68.6116
R4751 nv.n243 nv.n87 68.6116
R4752 nv.n286 nv.n56 68.6116
R4753 nv.n0 nv.t3 58.0466
R4754 nv.n62 nv.n56 55.4172
R4755 nv.n355 nv.n18 55.4172
R4756 nv.n232 nv.n87 55.4172
R4757 nv.n142 nv.n132 55.4172
R4758 nv.n289 nv.n288 39.2114
R4759 nv.n290 nv.n289 39.2114
R4760 nv.n354 nv.n25 39.2114
R4761 nv.n354 nv.n19 39.2114
R4762 nv.n0 nv.t0 38.065
R4763 nv.n233 nv.n231 30.5459
R4764 nv.n234 nv.n233 30.5459
R4765 nv.n141 nv.n133 30.5459
R4766 nv.n141 nv.n140 30.5459
R4767 nv.n384 nv.n383 18.4611
R4768 nv.n94 nv.n92 17.649
R4769 nv.n181 nv.n180 17.649
R4770 nv.n295 nv.n58 17.649
R4771 nv.n357 nv.n26 17.649
R4772 nv.n384 nv.n382 14.9331
R4773 nv.n138 nv.n136 13.1884
R4774 nv.n358 nv.n22 13.1884
R4775 nv.n236 nv.n235 13.1884
R4776 nv.n291 nv.n61 13.1884
R4777 nv.n97 nv.n94 13.1884
R4778 nv.n181 nv.n134 13.1884
R4779 nv.n295 nv.n59 13.1884
R4780 nv.n31 nv.n26 13.1884
R4781 nv.n176 nv.n175 12.4126
R4782 nv.n362 nv.n361 12.4126
R4783 nv.n241 nv.n89 12.4126
R4784 nv.n65 nv.n64 12.4126
R4785 nv.n225 nv.n98 12.4126
R4786 nv.n187 nv.n130 12.4126
R4787 nv.n301 nv.n54 12.4126
R4788 nv.n348 nv.n347 12.4126
R4789 nv.n147 nv.n139 11.6369
R4790 nv.n21 nv.n20 11.6369
R4791 nv.n240 nv.n90 11.6369
R4792 nv.n278 nv.n69 11.6369
R4793 nv.n224 nv.n99 11.6369
R4794 nv.n188 nv.n127 11.6369
R4795 nv.n303 nv.n302 11.6369
R4796 nv.n341 nv.n30 11.6369
R4797 nv.n180 nv.n136 11.249
R4798 nv.n358 nv.n357 11.249
R4799 nv.n236 nv.n92 11.249
R4800 nv.n291 nv.n58 11.249
R4801 nv.n169 nv.n148 10.8611
R4802 nv.n368 nv.n16 10.8611
R4803 nv.n247 nv.n85 10.8611
R4804 nv.n282 nv.n281 10.8611
R4805 nv.n221 nv.n220 10.8611
R4806 nv.n192 nv.n191 10.8611
R4807 nv.n308 nv.n51 10.8611
R4808 nv.n342 nv.n340 10.8611
R4809 nv.n168 nv.n149 10.0853
R4810 nv.n369 nv.n13 10.0853
R4811 nv.n249 nv.n248 10.0853
R4812 nv.n274 nv.n68 10.0853
R4813 nv.n107 nv.n103 10.0853
R4814 nv.n126 nv.n125 10.0853
R4815 nv.n307 nv.n52 10.0853
R4816 nv.n38 nv.n33 10.0853
R4817 nv.n165 nv.n164 9.30959
R4818 nv.n373 nv.n372 9.30959
R4819 nv.n254 nv.n82 9.30959
R4820 nv.n275 nv.n273 9.30959
R4821 nv.n214 nv.n108 9.30959
R4822 nv.n198 nv.n121 9.30959
R4823 nv.n314 nv.n47 9.30959
R4824 nv.n334 nv.n333 9.30959
R4825 nv.n156 nv.n155 9.3005
R4826 nv.n152 nv.n151 9.3005
R4827 nv.n166 nv.n165 9.3005
R4828 nv.n168 nv.n167 9.3005
R4829 nv.n150 nv.n148 9.3005
R4830 nv.n139 nv.n137 9.3005
R4831 nv.n177 nv.n176 9.3005
R4832 nv.n178 nv.n136 9.3005
R4833 nv.n237 nv.n236 9.3005
R4834 nv.n238 nv.n89 9.3005
R4835 nv.n240 nv.n239 9.3005
R4836 nv.n85 nv.n84 9.3005
R4837 nv.n250 nv.n249 9.3005
R4838 nv.n251 nv.n82 9.3005
R4839 nv.n253 nv.n252 9.3005
R4840 nv.n78 nv.n77 9.3005
R4841 nv.n263 nv.n262 9.3005
R4842 nv.n264 nv.n75 9.3005
R4843 nv.n266 nv.n265 9.3005
R4844 nv.n71 nv.n70 9.3005
R4845 nv.n276 nv.n275 9.3005
R4846 nv.n277 nv.n68 9.3005
R4847 nv.n281 nv.n280 9.3005
R4848 nv.n279 nv.n278 9.3005
R4849 nv.n64 nv.n60 9.3005
R4850 nv.n292 nv.n291 9.3005
R4851 nv.n92 nv.n91 9.3005
R4852 nv.n100 nv.n94 9.3005
R4853 nv.n101 nv.n98 9.3005
R4854 nv.n224 nv.n223 9.3005
R4855 nv.n222 nv.n221 9.3005
R4856 nv.n103 nv.n102 9.3005
R4857 nv.n110 nv.n108 9.3005
R4858 nv.n213 nv.n212 9.3005
R4859 nv.n211 nv.n210 9.3005
R4860 nv.n112 nv.n111 9.3005
R4861 nv.n119 nv.n117 9.3005
R4862 nv.n202 nv.n201 9.3005
R4863 nv.n200 nv.n199 9.3005
R4864 nv.n121 nv.n120 9.3005
R4865 nv.n128 nv.n126 9.3005
R4866 nv.n191 nv.n190 9.3005
R4867 nv.n189 nv.n188 9.3005
R4868 nv.n130 nv.n129 9.3005
R4869 nv.n181 nv.n135 9.3005
R4870 nv.n180 nv.n179 9.3005
R4871 nv.n295 nv.n294 9.3005
R4872 nv.n54 nv.n53 9.3005
R4873 nv.n304 nv.n303 9.3005
R4874 nv.n305 nv.n51 9.3005
R4875 nv.n307 nv.n306 9.3005
R4876 nv.n47 nv.n46 9.3005
R4877 nv.n317 nv.n316 9.3005
R4878 nv.n318 nv.n44 9.3005
R4879 nv.n320 nv.n319 9.3005
R4880 nv.n40 nv.n39 9.3005
R4881 nv.n330 nv.n329 9.3005
R4882 nv.n331 nv.n37 9.3005
R4883 nv.n333 nv.n332 9.3005
R4884 nv.n33 nv.n32 9.3005
R4885 nv.n343 nv.n342 9.3005
R4886 nv.n344 nv.n30 9.3005
R4887 nv.n347 nv.n346 9.3005
R4888 nv.n345 nv.n26 9.3005
R4889 nv.n357 nv.n24 9.3005
R4890 nv.n293 nv.n58 9.3005
R4891 nv.n359 nv.n358 9.3005
R4892 nv.n5 nv.n3 9.3005
R4893 nv.n14 nv.n12 9.3005
R4894 nv.n372 nv.n371 9.3005
R4895 nv.n370 nv.n369 9.3005
R4896 nv.n16 nv.n15 9.3005
R4897 nv.n23 nv.n21 9.3005
R4898 nv.n361 nv.n360 9.3005
R4899 nv.n157 nv.n2 9.3005
R4900 nv.n381 nv.n380 9.3005
R4901 nv.n154 nv.n152 8.53383
R4902 nv.n12 nv.n11 8.53383
R4903 nv.n253 nv.n83 8.53383
R4904 nv.n76 nv.n71 8.53383
R4905 nv.n213 nv.n109 8.53383
R4906 nv.n199 nv.n118 8.53383
R4907 nv.n316 nv.n315 8.53383
R4908 nv.n328 nv.n37 8.53383
R4909 nv.n158 nv.n156 7.75808
R4910 nv.n379 nv.n5 7.75808
R4911 nv.n260 nv.n78 7.75808
R4912 nv.n267 nv.n266 7.75808
R4913 nv.n210 nv.n209 7.75808
R4914 nv.n203 nv.n202 7.75808
R4915 nv.n321 nv.n44 7.75808
R4916 nv.n329 nv.n327 7.75808
R4917 nv.n157 nv.n4 6.98232
R4918 nv.n380 nv.n4 6.98232
R4919 nv.n262 nv.n261 6.98232
R4920 nv.n261 nv.n75 6.98232
R4921 nv.n116 nv.n112 6.98232
R4922 nv.n117 nv.n116 6.98232
R4923 nv.n320 nv.n45 6.98232
R4924 nv.n45 nv.n40 6.98232
R4925 nv.n158 nv.n157 6.20656
R4926 nv.n380 nv.n379 6.20656
R4927 nv.n262 nv.n260 6.20656
R4928 nv.n267 nv.n75 6.20656
R4929 nv.n209 nv.n112 6.20656
R4930 nv.n203 nv.n117 6.20656
R4931 nv.n321 nv.n320 6.20656
R4932 nv.n327 nv.n40 6.20656
R4933 nv.n156 nv.n154 5.4308
R4934 nv.n11 nv.n5 5.4308
R4935 nv.n83 nv.n78 5.4308
R4936 nv.n266 nv.n76 5.4308
R4937 nv.n210 nv.n109 5.4308
R4938 nv.n202 nv.n118 5.4308
R4939 nv.n315 nv.n44 5.4308
R4940 nv.n329 nv.n328 5.4308
R4941 nv.n164 nv.n152 4.65505
R4942 nv.n373 nv.n12 4.65505
R4943 nv.n254 nv.n253 4.65505
R4944 nv.n273 nv.n71 4.65505
R4945 nv.n214 nv.n213 4.65505
R4946 nv.n199 nv.n198 4.65505
R4947 nv.n316 nv.n314 4.65505
R4948 nv.n334 nv.n37 4.65505
R4949 nv.n165 nv.n149 3.87929
R4950 nv.n372 nv.n13 3.87929
R4951 nv.n248 nv.n82 3.87929
R4952 nv.n275 nv.n274 3.87929
R4953 nv.n108 nv.n107 3.87929
R4954 nv.n125 nv.n121 3.87929
R4955 nv.n52 nv.n47 3.87929
R4956 nv.n333 nv.n38 3.87929
R4957 nv nv.n1 3.58594
R4958 nv.n1 nv.n0 3.42279
R4959 nv.n169 nv.n168 3.10353
R4960 nv.n369 nv.n368 3.10353
R4961 nv.n249 nv.n247 3.10353
R4962 nv.n282 nv.n68 3.10353
R4963 nv.n220 nv.n103 3.10353
R4964 nv.n192 nv.n126 3.10353
R4965 nv.n308 nv.n307 3.10353
R4966 nv.n340 nv.n33 3.10353
R4967 nv.n148 nv.n147 2.32777
R4968 nv.n20 nv.n16 2.32777
R4969 nv.n90 nv.n85 2.32777
R4970 nv.n281 nv.n69 2.32777
R4971 nv.n221 nv.n99 2.32777
R4972 nv.n191 nv.n127 2.32777
R4973 nv.n302 nv.n51 2.32777
R4974 nv.n342 nv.n341 2.32777
R4975 nv.n175 nv.n139 1.55202
R4976 nv.n362 nv.n21 1.55202
R4977 nv.n241 nv.n240 1.55202
R4978 nv.n278 nv.n65 1.55202
R4979 nv.n225 nv.n224 1.55202
R4980 nv.n188 nv.n187 1.55202
R4981 nv.n303 nv.n301 1.55202
R4982 nv.n348 nv.n30 1.55202
R4983 nv.n1 nv.t1 0.801806
R4984 nv.n176 nv.n138 0.776258
R4985 nv.n361 nv.n22 0.776258
R4986 nv.n235 nv.n89 0.776258
R4987 nv.n64 nv.n61 0.776258
R4988 nv.n98 nv.n97 0.776258
R4989 nv.n134 nv.n130 0.776258
R4990 nv.n59 nv.n54 0.776258
R4991 nv.n347 nv.n31 0.776258
R4992 nv nv.n384 0.370625
R4993 nv.n100 nv.n91 0.196621
R4994 nv.n179 nv.n135 0.196621
R4995 nv.n294 nv.n293 0.196621
R4996 nv.n345 nv.n24 0.196621
R4997 nv.n178 nv.n177 0.155672
R4998 nv.n177 nv.n137 0.155672
R4999 nv.n150 nv.n137 0.155672
R5000 nv.n167 nv.n150 0.155672
R5001 nv.n167 nv.n166 0.155672
R5002 nv.n166 nv.n151 0.155672
R5003 nv.n155 nv.n151 0.155672
R5004 nv.n238 nv.n237 0.155672
R5005 nv.n239 nv.n238 0.155672
R5006 nv.n239 nv.n84 0.155672
R5007 nv.n250 nv.n84 0.155672
R5008 nv.n251 nv.n250 0.155672
R5009 nv.n252 nv.n251 0.155672
R5010 nv.n252 nv.n77 0.155672
R5011 nv.n263 nv.n77 0.155672
R5012 nv.n264 nv.n263 0.155672
R5013 nv.n265 nv.n264 0.155672
R5014 nv.n265 nv.n70 0.155672
R5015 nv.n276 nv.n70 0.155672
R5016 nv.n277 nv.n276 0.155672
R5017 nv.n280 nv.n277 0.155672
R5018 nv.n280 nv.n279 0.155672
R5019 nv.n279 nv.n60 0.155672
R5020 nv.n292 nv.n60 0.155672
R5021 nv.n101 nv.n100 0.155672
R5022 nv.n223 nv.n101 0.155672
R5023 nv.n223 nv.n222 0.155672
R5024 nv.n222 nv.n102 0.155672
R5025 nv.n110 nv.n102 0.155672
R5026 nv.n212 nv.n110 0.155672
R5027 nv.n212 nv.n211 0.155672
R5028 nv.n211 nv.n111 0.155672
R5029 nv.n119 nv.n111 0.155672
R5030 nv.n201 nv.n119 0.155672
R5031 nv.n201 nv.n200 0.155672
R5032 nv.n200 nv.n120 0.155672
R5033 nv.n128 nv.n120 0.155672
R5034 nv.n190 nv.n128 0.155672
R5035 nv.n190 nv.n189 0.155672
R5036 nv.n189 nv.n129 0.155672
R5037 nv.n135 nv.n129 0.155672
R5038 nv.n294 nv.n53 0.155672
R5039 nv.n304 nv.n53 0.155672
R5040 nv.n305 nv.n304 0.155672
R5041 nv.n306 nv.n305 0.155672
R5042 nv.n306 nv.n46 0.155672
R5043 nv.n317 nv.n46 0.155672
R5044 nv.n318 nv.n317 0.155672
R5045 nv.n319 nv.n318 0.155672
R5046 nv.n319 nv.n39 0.155672
R5047 nv.n330 nv.n39 0.155672
R5048 nv.n331 nv.n330 0.155672
R5049 nv.n332 nv.n331 0.155672
R5050 nv.n332 nv.n32 0.155672
R5051 nv.n343 nv.n32 0.155672
R5052 nv.n344 nv.n343 0.155672
R5053 nv.n346 nv.n344 0.155672
R5054 nv.n346 nv.n345 0.155672
R5055 nv.n14 nv.n3 0.155672
R5056 nv.n371 nv.n14 0.155672
R5057 nv.n371 nv.n370 0.155672
R5058 nv.n370 nv.n15 0.155672
R5059 nv.n23 nv.n15 0.155672
R5060 nv.n360 nv.n23 0.155672
R5061 nv.n360 nv.n359 0.155672
R5062 nv.n155 nv.n2 0.154652
R5063 nv.n381 nv.n3 0.154652
R5064 nv.n179 nv.n178 0.134121
R5065 nv.n237 nv.n91 0.134121
R5066 nv.n293 nv.n292 0.134121
R5067 nv.n359 nv.n24 0.134121
R5068 nv.n382 nv.n2 0.0597105
R5069 nv.n382 nv.n381 0.0597105
R5070 VSUB.n356 VSUB.t13 426687
R5071 VSUB.n357 VSUB.n356 357324
R5072 VSUB.n357 VSUB.t10 78117.5
R5073 VSUB.n385 VSUB.n31 43323.1
R5074 VSUB.n53 VSUB.n31 40659.2
R5075 VSUB.n356 VSUB.n31 35112
R5076 VSUB.n303 VSUB.n302 19735
R5077 VSUB.n80 VSUB.n53 19032.7
R5078 VSUB.n304 VSUB.n81 8877.46
R5079 VSUB.n81 VSUB.n80 8877.46
R5080 VSUB.t0 VSUB.n402 7825.2
R5081 VSUB.n82 VSUB.n81 7518.3
R5082 VSUB.n81 VSUB.n78 6677.46
R5083 VSUB.n385 VSUB.n384 4798.43
R5084 VSUB.n281 VSUB.n22 4337.96
R5085 VSUB.n281 VSUB.n82 4209.95
R5086 VSUB.n354 VSUB.t4 4162.51
R5087 VSUB.n282 VSUB.n281 4096.37
R5088 VSUB.n305 VSUB.n304 3016.34
R5089 VSUB.n304 VSUB.n303 2749.54
R5090 VSUB.n281 VSUB.t8 2720.76
R5091 VSUB.n303 VSUB.n82 2302.47
R5092 VSUB.n355 VSUB.n53 1914.48
R5093 VSUB.n355 VSUB.n52 1642.16
R5094 VSUB.n305 VSUB.n78 1366.54
R5095 VSUB.t1 VSUB.n305 1266.22
R5096 VSUB.n280 VSUB.n279 1179.84
R5097 VSUB.n80 VSUB.t18 1070
R5098 VSUB.n77 VSUB.n52 1052.14
R5099 VSUB.n280 VSUB.n111 1022.03
R5100 VSUB.n386 VSUB.n385 883.466
R5101 VSUB.t5 VSUB.t1 765.461
R5102 VSUB.n79 VSUB.n22 742.487
R5103 VSUB.t15 VSUB.n77 716.447
R5104 VSUB.n11 VSUB.n7 673.659
R5105 VSUB.n199 VSUB.n198 673.659
R5106 VSUB.n118 VSUB.n112 673.659
R5107 VSUB.n326 VSUB.n306 668.231
R5108 VSUB.n335 VSUB.n319 668.231
R5109 VSUB.n318 VSUB.n317 668.231
R5110 VSUB.n76 VSUB.n75 668.231
R5111 VSUB.n74 VSUB.n54 668.231
R5112 VSUB.n69 VSUB.n68 668.231
R5113 VSUB.n60 VSUB.n55 668.231
R5114 VSUB.n383 VSUB.n382 589.355
R5115 VSUB.n359 VSUB.n358 589.355
R5116 VSUB.n29 VSUB.n28 589.355
R5117 VSUB.n286 VSUB.n98 589.355
R5118 VSUB.n301 VSUB.n300 589.355
R5119 VSUB.n311 VSUB.n307 589.229
R5120 VSUB.n200 VSUB.n196 585
R5121 VSUB.n202 VSUB.n201 585
R5122 VSUB.n203 VSUB.n191 585
R5123 VSUB.n205 VSUB.n204 585
R5124 VSUB.n207 VSUB.n189 585
R5125 VSUB.n209 VSUB.n208 585
R5126 VSUB.n210 VSUB.n183 585
R5127 VSUB.n212 VSUB.n211 585
R5128 VSUB.n214 VSUB.n181 585
R5129 VSUB.n216 VSUB.n215 585
R5130 VSUB.n217 VSUB.n176 585
R5131 VSUB.n219 VSUB.n218 585
R5132 VSUB.n221 VSUB.n174 585
R5133 VSUB.n223 VSUB.n222 585
R5134 VSUB.n224 VSUB.n169 585
R5135 VSUB.n226 VSUB.n225 585
R5136 VSUB.n228 VSUB.n167 585
R5137 VSUB.n230 VSUB.n229 585
R5138 VSUB.n231 VSUB.n162 585
R5139 VSUB.n233 VSUB.n232 585
R5140 VSUB.n235 VSUB.n160 585
R5141 VSUB.n237 VSUB.n236 585
R5142 VSUB.n238 VSUB.n155 585
R5143 VSUB.n240 VSUB.n239 585
R5144 VSUB.n242 VSUB.n153 585
R5145 VSUB.n244 VSUB.n243 585
R5146 VSUB.n245 VSUB.n148 585
R5147 VSUB.n247 VSUB.n246 585
R5148 VSUB.n249 VSUB.n146 585
R5149 VSUB.n251 VSUB.n250 585
R5150 VSUB.n252 VSUB.n141 585
R5151 VSUB.n254 VSUB.n253 585
R5152 VSUB.n256 VSUB.n139 585
R5153 VSUB.n258 VSUB.n257 585
R5154 VSUB.n259 VSUB.n134 585
R5155 VSUB.n261 VSUB.n260 585
R5156 VSUB.n263 VSUB.n132 585
R5157 VSUB.n265 VSUB.n264 585
R5158 VSUB.n266 VSUB.n126 585
R5159 VSUB.n268 VSUB.n267 585
R5160 VSUB.n270 VSUB.n125 585
R5161 VSUB.n271 VSUB.n124 585
R5162 VSUB.n274 VSUB.n273 585
R5163 VSUB.n275 VSUB.n114 585
R5164 VSUB.n114 VSUB.n111 585
R5165 VSUB.n386 VSUB.n29 585
R5166 VSUB.n389 VSUB.n388 585
R5167 VSUB.n388 VSUB.n387 585
R5168 VSUB.n390 VSUB.n24 585
R5169 VSUB.n30 VSUB.n24 585
R5170 VSUB.n360 VSUB.n359 585
R5171 VSUB.n51 VSUB.n50 585
R5172 VSUB.n361 VSUB.n51 585
R5173 VSUB.n364 VSUB.n363 585
R5174 VSUB.n363 VSUB.n362 585
R5175 VSUB.n365 VSUB.n45 585
R5176 VSUB.n45 VSUB.n44 585
R5177 VSUB.n367 VSUB.n366 585
R5178 VSUB.n368 VSUB.n367 585
R5179 VSUB.n43 VSUB.n42 585
R5180 VSUB.n369 VSUB.n43 585
R5181 VSUB.n372 VSUB.n371 585
R5182 VSUB.n371 VSUB.n370 585
R5183 VSUB.n373 VSUB.n39 585
R5184 VSUB.n39 VSUB.n38 585
R5185 VSUB.n375 VSUB.n374 585
R5186 VSUB.n376 VSUB.n375 585
R5187 VSUB.n37 VSUB.n36 585
R5188 VSUB.n377 VSUB.n37 585
R5189 VSUB.n380 VSUB.n379 585
R5190 VSUB.n379 VSUB.n378 585
R5191 VSUB.n34 VSUB.n33 585
R5192 VSUB.n33 VSUB.n32 585
R5193 VSUB.n384 VSUB.n383 585
R5194 VSUB.n277 VSUB.n276 585
R5195 VSUB.n115 VSUB.n113 585
R5196 VSUB.n117 VSUB.n116 585
R5197 VSUB.n392 VSUB.n391 585
R5198 VSUB.n394 VSUB.n23 585
R5199 VSUB.n395 VSUB.n5 585
R5200 VSUB.n398 VSUB.n397 585
R5201 VSUB.n6 VSUB.n4 585
R5202 VSUB.n20 VSUB.n19 585
R5203 VSUB.n10 VSUB.n9 585
R5204 VSUB.n15 VSUB.n14 585
R5205 VSUB.n13 VSUB.n12 585
R5206 VSUB.n58 VSUB.n57 585
R5207 VSUB.n66 VSUB.n65 585
R5208 VSUB.n64 VSUB.n63 585
R5209 VSUB.n62 VSUB.n61 585
R5210 VSUB.n71 VSUB.n70 585
R5211 VSUB.n73 VSUB.n72 585
R5212 VSUB.n310 VSUB.n309 585
R5213 VSUB.n315 VSUB.n314 585
R5214 VSUB.n313 VSUB.n312 585
R5215 VSUB.n354 VSUB.n307 585
R5216 VSUB.n325 VSUB.n324 585
R5217 VSUB.n352 VSUB.n351 585
R5218 VSUB.n350 VSUB.n323 585
R5219 VSUB.n349 VSUB.n348 585
R5220 VSUB.n347 VSUB.n346 585
R5221 VSUB.n345 VSUB.n344 585
R5222 VSUB.n343 VSUB.n342 585
R5223 VSUB.n341 VSUB.n340 585
R5224 VSUB.n339 VSUB.n338 585
R5225 VSUB.n337 VSUB.n336 585
R5226 VSUB.n282 VSUB.n98 585
R5227 VSUB.n285 VSUB.n284 585
R5228 VSUB.n284 VSUB.n283 585
R5229 VSUB.n99 VSUB.n97 585
R5230 VSUB.n110 VSUB.n99 585
R5231 VSUB.n289 VSUB.n96 585
R5232 VSUB.n109 VSUB.n96 585
R5233 VSUB.n290 VSUB.n95 585
R5234 VSUB.n108 VSUB.n95 585
R5235 VSUB.n291 VSUB.n94 585
R5236 VSUB.n107 VSUB.n94 585
R5237 VSUB.n105 VSUB.n92 585
R5238 VSUB.n106 VSUB.n105 585
R5239 VSUB.n104 VSUB.n90 585
R5240 VSUB.n104 VSUB.n103 585
R5241 VSUB.n296 VSUB.n89 585
R5242 VSUB.n102 VSUB.n89 585
R5243 VSUB.n297 VSUB.n88 585
R5244 VSUB.n101 VSUB.n88 585
R5245 VSUB.n298 VSUB.n87 585
R5246 VSUB.n100 VSUB.n87 585
R5247 VSUB.n85 VSUB.n84 585
R5248 VSUB.n84 VSUB.n83 585
R5249 VSUB.n302 VSUB.n301 585
R5250 VSUB.t15 VSUB.n354 524.819
R5251 VSUB.t4 VSUB.t5 423.238
R5252 VSUB.t6 VSUB.t10 352.423
R5253 VSUB.n355 VSUB.t15 305.981
R5254 VSUB.t13 VSUB.n355 305.981
R5255 VSUB.n360 VSUB.n357 294.488
R5256 VSUB.n77 VSUB.n69 253
R5257 VSUB.n77 VSUB.n56 253
R5258 VSUB.n77 VSUB.n55 253
R5259 VSUB.n77 VSUB.n76 253
R5260 VSUB.n77 VSUB.n54 253
R5261 VSUB.n354 VSUB.n318 253
R5262 VSUB.n354 VSUB.n308 253
R5263 VSUB.n354 VSUB.n306 253
R5264 VSUB.n354 VSUB.n353 253
R5265 VSUB.n354 VSUB.n322 253
R5266 VSUB.n354 VSUB.n321 253
R5267 VSUB.n354 VSUB.n320 253
R5268 VSUB.n354 VSUB.n319 253
R5269 VSUB.n199 VSUB.n111 250.349
R5270 VSUB.n197 VSUB.n111 250.349
R5271 VSUB.n206 VSUB.n111 250.349
R5272 VSUB.n190 VSUB.n111 250.349
R5273 VSUB.n213 VSUB.n111 250.349
R5274 VSUB.n182 VSUB.n111 250.349
R5275 VSUB.n220 VSUB.n111 250.349
R5276 VSUB.n175 VSUB.n111 250.349
R5277 VSUB.n227 VSUB.n111 250.349
R5278 VSUB.n168 VSUB.n111 250.349
R5279 VSUB.n234 VSUB.n111 250.349
R5280 VSUB.n161 VSUB.n111 250.349
R5281 VSUB.n241 VSUB.n111 250.349
R5282 VSUB.n154 VSUB.n111 250.349
R5283 VSUB.n248 VSUB.n111 250.349
R5284 VSUB.n147 VSUB.n111 250.349
R5285 VSUB.n255 VSUB.n111 250.349
R5286 VSUB.n140 VSUB.n111 250.349
R5287 VSUB.n262 VSUB.n111 250.349
R5288 VSUB.n133 VSUB.n111 250.349
R5289 VSUB.n269 VSUB.n111 250.349
R5290 VSUB.n272 VSUB.n111 250.349
R5291 VSUB.n279 VSUB.n278 250.349
R5292 VSUB.n279 VSUB.n112 250.349
R5293 VSUB.n393 VSUB.n22 250.349
R5294 VSUB.n396 VSUB.n22 250.349
R5295 VSUB.n22 VSUB.n21 250.349
R5296 VSUB.n22 VSUB.n8 250.349
R5297 VSUB.n22 VSUB.n7 250.349
R5298 VSUB.n78 VSUB.n52 226.107
R5299 VSUB.n383 VSUB.n33 197
R5300 VSUB.n379 VSUB.n33 197
R5301 VSUB.n379 VSUB.n37 197
R5302 VSUB.n375 VSUB.n37 197
R5303 VSUB.n375 VSUB.n39 197
R5304 VSUB.n371 VSUB.n39 197
R5305 VSUB.n371 VSUB.n43 197
R5306 VSUB.n367 VSUB.n43 197
R5307 VSUB.n367 VSUB.n45 197
R5308 VSUB.n363 VSUB.n45 197
R5309 VSUB.n363 VSUB.n51 197
R5310 VSUB.n359 VSUB.n51 197
R5311 VSUB.n14 VSUB.n13 197
R5312 VSUB.n20 VSUB.n9 197
R5313 VSUB.n397 VSUB.n6 197
R5314 VSUB.n395 VSUB.n394 197
R5315 VSUB.n392 VSUB.n24 197
R5316 VSUB.n388 VSUB.n24 197
R5317 VSUB.n388 VSUB.n29 197
R5318 VSUB.n116 VSUB.n113 197
R5319 VSUB.n277 VSUB.n114 197
R5320 VSUB.n273 VSUB.n114 197
R5321 VSUB.n271 VSUB.n270 197
R5322 VSUB.n268 VSUB.n126 197
R5323 VSUB.n264 VSUB.n263 197
R5324 VSUB.n261 VSUB.n134 197
R5325 VSUB.n257 VSUB.n256 197
R5326 VSUB.n254 VSUB.n141 197
R5327 VSUB.n250 VSUB.n249 197
R5328 VSUB.n247 VSUB.n148 197
R5329 VSUB.n243 VSUB.n242 197
R5330 VSUB.n240 VSUB.n155 197
R5331 VSUB.n236 VSUB.n235 197
R5332 VSUB.n233 VSUB.n162 197
R5333 VSUB.n229 VSUB.n228 197
R5334 VSUB.n226 VSUB.n169 197
R5335 VSUB.n222 VSUB.n221 197
R5336 VSUB.n219 VSUB.n176 197
R5337 VSUB.n215 VSUB.n214 197
R5338 VSUB.n212 VSUB.n183 197
R5339 VSUB.n208 VSUB.n207 197
R5340 VSUB.n205 VSUB.n191 197
R5341 VSUB.n201 VSUB.n200 197
R5342 VSUB.n301 VSUB.n84 197
R5343 VSUB.n87 VSUB.n84 197
R5344 VSUB.n88 VSUB.n87 197
R5345 VSUB.n89 VSUB.n88 197
R5346 VSUB.n104 VSUB.n89 197
R5347 VSUB.n105 VSUB.n104 197
R5348 VSUB.n105 VSUB.n94 197
R5349 VSUB.n95 VSUB.n94 197
R5350 VSUB.n96 VSUB.n95 197
R5351 VSUB.n99 VSUB.n96 197
R5352 VSUB.n284 VSUB.n99 197
R5353 VSUB.n284 VSUB.n98 197
R5354 VSUB.n352 VSUB.n324 182.673
R5355 VSUB.n348 VSUB.n323 182.673
R5356 VSUB.n346 VSUB.n345 182.673
R5357 VSUB.n342 VSUB.n341 182.673
R5358 VSUB.n338 VSUB.n337 182.673
R5359 VSUB.n314 VSUB.n309 182.673
R5360 VSUB.n312 VSUB.n307 182.673
R5361 VSUB.n72 VSUB.n70 182.673
R5362 VSUB.n65 VSUB.n57 182.673
R5363 VSUB.n63 VSUB.n62 182.673
R5364 VSUB.n302 VSUB.n83 180.328
R5365 VSUB.n100 VSUB.n83 180.328
R5366 VSUB.n102 VSUB.n101 180.328
R5367 VSUB.n103 VSUB.n102 180.328
R5368 VSUB.n106 VSUB.n103 180.328
R5369 VSUB.n107 VSUB.n106 180.328
R5370 VSUB.n108 VSUB.n107 180.328
R5371 VSUB.n109 VSUB.n108 180.328
R5372 VSUB.n283 VSUB.n110 180.328
R5373 VSUB.n283 VSUB.n282 180.328
R5374 VSUB.n387 VSUB.n30 173.228
R5375 VSUB.n387 VSUB.n386 173.228
R5376 VSUB.n384 VSUB.n32 173.228
R5377 VSUB.n378 VSUB.n32 173.228
R5378 VSUB.n377 VSUB.n376 173.228
R5379 VSUB.n376 VSUB.n38 173.228
R5380 VSUB.n370 VSUB.n38 173.228
R5381 VSUB.n370 VSUB.n369 173.228
R5382 VSUB.n369 VSUB.n368 173.228
R5383 VSUB.n368 VSUB.n44 173.228
R5384 VSUB.n362 VSUB.n361 173.228
R5385 VSUB.n361 VSUB.n360 173.228
R5386 VSUB.t19 VSUB.n100 162.296
R5387 VSUB.n110 VSUB.t21 162.296
R5388 VSUB.n378 VSUB.t3 155.906
R5389 VSUB.n362 VSUB.t2 155.906
R5390 VSUB.t8 VSUB.n280 111.882
R5391 VSUB.n280 VSUB.t6 96.9168
R5392 VSUB.n13 VSUB.n7 84.306
R5393 VSUB.n9 VSUB.n8 84.306
R5394 VSUB.n21 VSUB.n6 84.306
R5395 VSUB.n396 VSUB.n395 84.306
R5396 VSUB.n393 VSUB.n392 84.306
R5397 VSUB.n116 VSUB.n112 84.306
R5398 VSUB.n278 VSUB.n277 84.306
R5399 VSUB.n272 VSUB.n271 84.306
R5400 VSUB.n269 VSUB.n268 84.306
R5401 VSUB.n264 VSUB.n133 84.306
R5402 VSUB.n262 VSUB.n261 84.306
R5403 VSUB.n257 VSUB.n140 84.306
R5404 VSUB.n255 VSUB.n254 84.306
R5405 VSUB.n250 VSUB.n147 84.306
R5406 VSUB.n248 VSUB.n247 84.306
R5407 VSUB.n243 VSUB.n154 84.306
R5408 VSUB.n241 VSUB.n240 84.306
R5409 VSUB.n236 VSUB.n161 84.306
R5410 VSUB.n234 VSUB.n233 84.306
R5411 VSUB.n229 VSUB.n168 84.306
R5412 VSUB.n227 VSUB.n226 84.306
R5413 VSUB.n222 VSUB.n175 84.306
R5414 VSUB.n220 VSUB.n219 84.306
R5415 VSUB.n215 VSUB.n182 84.306
R5416 VSUB.n213 VSUB.n212 84.306
R5417 VSUB.n208 VSUB.n190 84.306
R5418 VSUB.n206 VSUB.n205 84.306
R5419 VSUB.n201 VSUB.n197 84.306
R5420 VSUB.n200 VSUB.n199 84.306
R5421 VSUB.n197 VSUB.n191 84.306
R5422 VSUB.n207 VSUB.n206 84.306
R5423 VSUB.n190 VSUB.n183 84.306
R5424 VSUB.n214 VSUB.n213 84.306
R5425 VSUB.n182 VSUB.n176 84.306
R5426 VSUB.n221 VSUB.n220 84.306
R5427 VSUB.n175 VSUB.n169 84.306
R5428 VSUB.n228 VSUB.n227 84.306
R5429 VSUB.n168 VSUB.n162 84.306
R5430 VSUB.n235 VSUB.n234 84.306
R5431 VSUB.n161 VSUB.n155 84.306
R5432 VSUB.n242 VSUB.n241 84.306
R5433 VSUB.n154 VSUB.n148 84.306
R5434 VSUB.n249 VSUB.n248 84.306
R5435 VSUB.n147 VSUB.n141 84.306
R5436 VSUB.n256 VSUB.n255 84.306
R5437 VSUB.n140 VSUB.n134 84.306
R5438 VSUB.n263 VSUB.n262 84.306
R5439 VSUB.n133 VSUB.n126 84.306
R5440 VSUB.n270 VSUB.n269 84.306
R5441 VSUB.n273 VSUB.n272 84.306
R5442 VSUB.n278 VSUB.n113 84.306
R5443 VSUB.n394 VSUB.n393 84.306
R5444 VSUB.n397 VSUB.n396 84.306
R5445 VSUB.n21 VSUB.n20 84.306
R5446 VSUB.n14 VSUB.n8 84.306
R5447 VSUB.n324 VSUB.n306 79.0028
R5448 VSUB.n353 VSUB.n352 79.0028
R5449 VSUB.n348 VSUB.n322 79.0028
R5450 VSUB.n345 VSUB.n321 79.0028
R5451 VSUB.n341 VSUB.n320 79.0028
R5452 VSUB.n337 VSUB.n319 79.0028
R5453 VSUB.n314 VSUB.n308 79.0028
R5454 VSUB.n65 VSUB.n56 79.0028
R5455 VSUB.n62 VSUB.n55 79.0028
R5456 VSUB.n69 VSUB.n57 79.0028
R5457 VSUB.n63 VSUB.n56 79.0028
R5458 VSUB.n76 VSUB.n70 79.0028
R5459 VSUB.n72 VSUB.n54 79.0028
R5460 VSUB.n318 VSUB.n309 79.0028
R5461 VSUB.n312 VSUB.n308 79.0028
R5462 VSUB.n353 VSUB.n323 79.0028
R5463 VSUB.n346 VSUB.n322 79.0028
R5464 VSUB.n342 VSUB.n321 79.0028
R5465 VSUB.n338 VSUB.n320 79.0028
R5466 VSUB.t18 VSUB.n79 72.8061
R5467 VSUB.n403 VSUB.t17 31.7373
R5468 VSUB.n403 VSUB.t0 30.3931
R5469 VSUB.n188 VSUB.n187 30.1455
R5470 VSUB.n293 VSUB.n91 28.8955
R5471 VSUB.n101 VSUB.t19 18.0333
R5472 VSUB.t21 VSUB.n109 18.0333
R5473 VSUB.t3 VSUB.n377 17.3233
R5474 VSUB.t2 VSUB.n44 17.3233
R5475 VSUB.n380 VSUB.n34 16.0005
R5476 VSUB.n380 VSUB.n36 16.0005
R5477 VSUB.n374 VSUB.n36 16.0005
R5478 VSUB.n374 VSUB.n373 16.0005
R5479 VSUB.n373 VSUB.n372 16.0005
R5480 VSUB.n372 VSUB.n42 16.0005
R5481 VSUB.n366 VSUB.n42 16.0005
R5482 VSUB.n366 VSUB.n365 16.0005
R5483 VSUB.n365 VSUB.n364 16.0005
R5484 VSUB.n364 VSUB.n50 16.0005
R5485 VSUB.n15 VSUB.n12 16.0005
R5486 VSUB.n15 VSUB.n10 16.0005
R5487 VSUB.n19 VSUB.n10 16.0005
R5488 VSUB.n19 VSUB.n4 16.0005
R5489 VSUB.n398 VSUB.n4 16.0005
R5490 VSUB.n398 VSUB.n5 16.0005
R5491 VSUB.n23 VSUB.n5 16.0005
R5492 VSUB.n391 VSUB.n23 16.0005
R5493 VSUB.n391 VSUB.n390 16.0005
R5494 VSUB.n390 VSUB.n389 16.0005
R5495 VSUB.n117 VSUB.n115 16.0005
R5496 VSUB.n276 VSUB.n115 16.0005
R5497 VSUB.n276 VSUB.n275 16.0005
R5498 VSUB.n275 VSUB.n274 16.0005
R5499 VSUB.n274 VSUB.n124 16.0005
R5500 VSUB.n125 VSUB.n124 16.0005
R5501 VSUB.n267 VSUB.n125 16.0005
R5502 VSUB.n267 VSUB.n266 16.0005
R5503 VSUB.n266 VSUB.n265 16.0005
R5504 VSUB.n265 VSUB.n132 16.0005
R5505 VSUB.n260 VSUB.n132 16.0005
R5506 VSUB.n260 VSUB.n259 16.0005
R5507 VSUB.n259 VSUB.n258 16.0005
R5508 VSUB.n258 VSUB.n139 16.0005
R5509 VSUB.n253 VSUB.n139 16.0005
R5510 VSUB.n253 VSUB.n252 16.0005
R5511 VSUB.n252 VSUB.n251 16.0005
R5512 VSUB.n251 VSUB.n146 16.0005
R5513 VSUB.n246 VSUB.n146 16.0005
R5514 VSUB.n246 VSUB.n245 16.0005
R5515 VSUB.n245 VSUB.n244 16.0005
R5516 VSUB.n244 VSUB.n153 16.0005
R5517 VSUB.n239 VSUB.n153 16.0005
R5518 VSUB.n239 VSUB.n238 16.0005
R5519 VSUB.n238 VSUB.n237 16.0005
R5520 VSUB.n237 VSUB.n160 16.0005
R5521 VSUB.n232 VSUB.n160 16.0005
R5522 VSUB.n232 VSUB.n231 16.0005
R5523 VSUB.n231 VSUB.n230 16.0005
R5524 VSUB.n230 VSUB.n167 16.0005
R5525 VSUB.n225 VSUB.n167 16.0005
R5526 VSUB.n225 VSUB.n224 16.0005
R5527 VSUB.n224 VSUB.n223 16.0005
R5528 VSUB.n223 VSUB.n174 16.0005
R5529 VSUB.n218 VSUB.n174 16.0005
R5530 VSUB.n218 VSUB.n217 16.0005
R5531 VSUB.n217 VSUB.n216 16.0005
R5532 VSUB.n216 VSUB.n181 16.0005
R5533 VSUB.n211 VSUB.n181 16.0005
R5534 VSUB.n211 VSUB.n210 16.0005
R5535 VSUB.n210 VSUB.n209 16.0005
R5536 VSUB.n209 VSUB.n189 16.0005
R5537 VSUB.n204 VSUB.n189 16.0005
R5538 VSUB.n204 VSUB.n203 16.0005
R5539 VSUB.n203 VSUB.n202 16.0005
R5540 VSUB.n202 VSUB.n196 16.0005
R5541 VSUB.n298 VSUB.n85 16.0005
R5542 VSUB.n298 VSUB.n297 16.0005
R5543 VSUB.n297 VSUB.n296 16.0005
R5544 VSUB.n296 VSUB.n90 16.0005
R5545 VSUB.n92 VSUB.n90 16.0005
R5546 VSUB.n291 VSUB.n92 16.0005
R5547 VSUB.n291 VSUB.n290 16.0005
R5548 VSUB.n290 VSUB.n289 16.0005
R5549 VSUB.n289 VSUB.n97 16.0005
R5550 VSUB.n285 VSUB.n97 16.0005
R5551 VSUB.n91 VSUB.t20 15.6755
R5552 VSUB.n91 VSUB.t22 15.6755
R5553 VSUB.n187 VSUB.t12 15.6755
R5554 VSUB.n187 VSUB.t11 15.6755
R5555 VSUB.n351 VSUB.n325 15.1819
R5556 VSUB.n351 VSUB.n350 15.1819
R5557 VSUB.n350 VSUB.n349 15.1819
R5558 VSUB.n349 VSUB.n347 15.1819
R5559 VSUB.n347 VSUB.n344 15.1819
R5560 VSUB.n344 VSUB.n343 15.1819
R5561 VSUB.n343 VSUB.n340 15.1819
R5562 VSUB.n340 VSUB.n339 15.1819
R5563 VSUB.n339 VSUB.n336 15.1819
R5564 VSUB.n315 VSUB.n310 15.1819
R5565 VSUB.n315 VSUB.n313 15.1819
R5566 VSUB.n73 VSUB.n71 15.1819
R5567 VSUB.n66 VSUB.n58 15.1819
R5568 VSUB.n66 VSUB.n64 15.1819
R5569 VSUB.n64 VSUB.n61 15.1819
R5570 VSUB.n122 VSUB.n121 14.5191
R5571 VSUB.n188 VSUB.n0 14.2047
R5572 VSUB.n406 VSUB.t14 13.4829
R5573 VSUB.n406 VSUB.t16 13.0129
R5574 VSUB.n405 VSUB.t23 12.1907
R5575 VSUB.n400 VSUB.n1 10.3442
R5576 VSUB.n401 VSUB.n400 9.5158
R5577 VSUB.n351 VSUB.n327 9.3005
R5578 VSUB.n350 VSUB.n328 9.3005
R5579 VSUB.n349 VSUB.n329 9.3005
R5580 VSUB.n347 VSUB.n330 9.3005
R5581 VSUB.n344 VSUB.n331 9.3005
R5582 VSUB.n343 VSUB.n332 9.3005
R5583 VSUB.n340 VSUB.n333 9.3005
R5584 VSUB.n339 VSUB.n334 9.3005
R5585 VSUB.n316 VSUB.n315 9.3005
R5586 VSUB.n64 VSUB.n59 9.3005
R5587 VSUB.n67 VSUB.n66 9.3005
R5588 VSUB.n381 VSUB.n380 9.3005
R5589 VSUB.n36 VSUB.n35 9.3005
R5590 VSUB.n374 VSUB.n40 9.3005
R5591 VSUB.n373 VSUB.n41 9.3005
R5592 VSUB.n372 VSUB.n1 9.3005
R5593 VSUB.n46 VSUB.n42 9.3005
R5594 VSUB.n366 VSUB.n47 9.3005
R5595 VSUB.n365 VSUB.n48 9.3005
R5596 VSUB.n364 VSUB.n49 9.3005
R5597 VSUB.n16 VSUB.n15 9.3005
R5598 VSUB.n17 VSUB.n10 9.3005
R5599 VSUB.n19 VSUB.n18 9.3005
R5600 VSUB.n4 VSUB.n2 9.3005
R5601 VSUB.n399 VSUB.n398 9.3005
R5602 VSUB.n5 VSUB.n3 9.3005
R5603 VSUB.n25 VSUB.n23 9.3005
R5604 VSUB.n391 VSUB.n26 9.3005
R5605 VSUB.n390 VSUB.n27 9.3005
R5606 VSUB.n119 VSUB.n115 9.3005
R5607 VSUB.n276 VSUB.n120 9.3005
R5608 VSUB.n275 VSUB.n122 9.3005
R5609 VSUB.n274 VSUB.n123 9.3005
R5610 VSUB.n127 VSUB.n124 9.3005
R5611 VSUB.n128 VSUB.n125 9.3005
R5612 VSUB.n267 VSUB.n129 9.3005
R5613 VSUB.n266 VSUB.n130 9.3005
R5614 VSUB.n265 VSUB.n131 9.3005
R5615 VSUB.n135 VSUB.n132 9.3005
R5616 VSUB.n260 VSUB.n136 9.3005
R5617 VSUB.n259 VSUB.n137 9.3005
R5618 VSUB.n258 VSUB.n138 9.3005
R5619 VSUB.n142 VSUB.n139 9.3005
R5620 VSUB.n253 VSUB.n143 9.3005
R5621 VSUB.n252 VSUB.n144 9.3005
R5622 VSUB.n251 VSUB.n145 9.3005
R5623 VSUB.n149 VSUB.n146 9.3005
R5624 VSUB.n246 VSUB.n150 9.3005
R5625 VSUB.n245 VSUB.n151 9.3005
R5626 VSUB.n244 VSUB.n152 9.3005
R5627 VSUB.n156 VSUB.n153 9.3005
R5628 VSUB.n239 VSUB.n157 9.3005
R5629 VSUB.n238 VSUB.n158 9.3005
R5630 VSUB.n237 VSUB.n159 9.3005
R5631 VSUB.n163 VSUB.n160 9.3005
R5632 VSUB.n232 VSUB.n164 9.3005
R5633 VSUB.n231 VSUB.n165 9.3005
R5634 VSUB.n230 VSUB.n166 9.3005
R5635 VSUB.n170 VSUB.n167 9.3005
R5636 VSUB.n225 VSUB.n171 9.3005
R5637 VSUB.n224 VSUB.n172 9.3005
R5638 VSUB.n223 VSUB.n173 9.3005
R5639 VSUB.n177 VSUB.n174 9.3005
R5640 VSUB.n218 VSUB.n178 9.3005
R5641 VSUB.n217 VSUB.n179 9.3005
R5642 VSUB.n216 VSUB.n180 9.3005
R5643 VSUB.n184 VSUB.n181 9.3005
R5644 VSUB.n211 VSUB.n185 9.3005
R5645 VSUB.n210 VSUB.n186 9.3005
R5646 VSUB.n209 VSUB.n188 9.3005
R5647 VSUB.n192 VSUB.n189 9.3005
R5648 VSUB.n204 VSUB.n193 9.3005
R5649 VSUB.n203 VSUB.n194 9.3005
R5650 VSUB.n202 VSUB.n195 9.3005
R5651 VSUB.n299 VSUB.n298 9.3005
R5652 VSUB.n297 VSUB.n86 9.3005
R5653 VSUB.n296 VSUB.n295 9.3005
R5654 VSUB.n294 VSUB.n90 9.3005
R5655 VSUB.n293 VSUB.n92 9.3005
R5656 VSUB.n292 VSUB.n291 9.3005
R5657 VSUB.n290 VSUB.n93 9.3005
R5658 VSUB.n289 VSUB.n288 9.3005
R5659 VSUB.n287 VSUB.n97 9.3005
R5660 VSUB.n401 VSUB.n0 8.6698
R5661 VSUB.n400 VSUB.n399 8.23862
R5662 VSUB.n293 VSUB.n0 8.1605
R5663 VSUB.n121 VSUB.t9 7.838
R5664 VSUB.n121 VSUB.t7 7.838
R5665 VSUB.n79 VSUB.n30 6.92963
R5666 VSUB.n407 VSUB.n406 6.76348
R5667 VSUB.n404 VSUB.n403 5.91936
R5668 VSUB.n75 VSUB.n74 5.32922
R5669 VSUB.n382 VSUB.n34 4.28224
R5670 VSUB.n358 VSUB.n50 4.28224
R5671 VSUB.n12 VSUB.n11 4.28224
R5672 VSUB.n389 VSUB.n28 4.28224
R5673 VSUB.n118 VSUB.n117 4.28224
R5674 VSUB.n198 VSUB.n196 4.28224
R5675 VSUB.n300 VSUB.n85 4.28224
R5676 VSUB.n286 VSUB.n285 4.28224
R5677 VSUB.n326 VSUB.n325 4.16217
R5678 VSUB.n336 VSUB.n335 4.16217
R5679 VSUB.n313 VSUB.n311 4.16217
R5680 VSUB.n317 VSUB.n310 4.16217
R5681 VSUB.n74 VSUB.n73 4.16217
R5682 VSUB.n75 VSUB.n71 4.16217
R5683 VSUB.n61 VSUB.n60 4.16217
R5684 VSUB.n68 VSUB.n58 4.16217
R5685 VSUB.n327 VSUB.n326 2.73899
R5686 VSUB.n335 VSUB.n334 2.73899
R5687 VSUB.n317 VSUB.n316 2.73899
R5688 VSUB.n316 VSUB.n311 2.73899
R5689 VSUB.n68 VSUB.n67 2.73899
R5690 VSUB.n60 VSUB.n59 2.73899
R5691 VSUB.n382 VSUB.n381 2.68753
R5692 VSUB.n358 VSUB.n49 2.68753
R5693 VSUB.n16 VSUB.n11 2.68753
R5694 VSUB.n28 VSUB.n27 2.68753
R5695 VSUB.n119 VSUB.n118 2.68753
R5696 VSUB.n198 VSUB.n195 2.68753
R5697 VSUB.n300 VSUB.n299 2.68753
R5698 VSUB.n287 VSUB.n286 2.68753
R5699 VSUB.n407 VSUB.n405 2.50717
R5700 VSUB VSUB.n407 1.528
R5701 VSUB.n405 VSUB.n404 1.293
R5702 VSUB.n404 VSUB.n401 0.259
R5703 VSUB.n381 VSUB.n35 0.15675
R5704 VSUB.n40 VSUB.n35 0.15675
R5705 VSUB.n41 VSUB.n40 0.15675
R5706 VSUB.n41 VSUB.n1 0.15675
R5707 VSUB.n46 VSUB.n1 0.15675
R5708 VSUB.n47 VSUB.n46 0.15675
R5709 VSUB.n48 VSUB.n47 0.15675
R5710 VSUB.n49 VSUB.n48 0.15675
R5711 VSUB.n17 VSUB.n16 0.15675
R5712 VSUB.n18 VSUB.n17 0.15675
R5713 VSUB.n18 VSUB.n2 0.15675
R5714 VSUB.n399 VSUB.n2 0.15675
R5715 VSUB.n399 VSUB.n3 0.15675
R5716 VSUB.n25 VSUB.n3 0.15675
R5717 VSUB.n26 VSUB.n25 0.15675
R5718 VSUB.n27 VSUB.n26 0.15675
R5719 VSUB.n120 VSUB.n119 0.15675
R5720 VSUB.n122 VSUB.n120 0.15675
R5721 VSUB.n123 VSUB.n122 0.15675
R5722 VSUB.n127 VSUB.n123 0.15675
R5723 VSUB.n128 VSUB.n127 0.15675
R5724 VSUB.n129 VSUB.n128 0.15675
R5725 VSUB.n130 VSUB.n129 0.15675
R5726 VSUB.n131 VSUB.n130 0.15675
R5727 VSUB.n135 VSUB.n131 0.15675
R5728 VSUB.n136 VSUB.n135 0.15675
R5729 VSUB.n137 VSUB.n136 0.15675
R5730 VSUB.n138 VSUB.n137 0.15675
R5731 VSUB.n142 VSUB.n138 0.15675
R5732 VSUB.n143 VSUB.n142 0.15675
R5733 VSUB.n144 VSUB.n143 0.15675
R5734 VSUB.n145 VSUB.n144 0.15675
R5735 VSUB.n149 VSUB.n145 0.15675
R5736 VSUB.n150 VSUB.n149 0.15675
R5737 VSUB.n151 VSUB.n150 0.15675
R5738 VSUB.n152 VSUB.n151 0.15675
R5739 VSUB.n156 VSUB.n152 0.15675
R5740 VSUB.n157 VSUB.n156 0.15675
R5741 VSUB.n158 VSUB.n157 0.15675
R5742 VSUB.n159 VSUB.n158 0.15675
R5743 VSUB.n163 VSUB.n159 0.15675
R5744 VSUB.n164 VSUB.n163 0.15675
R5745 VSUB.n165 VSUB.n164 0.15675
R5746 VSUB.n166 VSUB.n165 0.15675
R5747 VSUB.n170 VSUB.n166 0.15675
R5748 VSUB.n171 VSUB.n170 0.15675
R5749 VSUB.n172 VSUB.n171 0.15675
R5750 VSUB.n173 VSUB.n172 0.15675
R5751 VSUB.n177 VSUB.n173 0.15675
R5752 VSUB.n178 VSUB.n177 0.15675
R5753 VSUB.n179 VSUB.n178 0.15675
R5754 VSUB.n180 VSUB.n179 0.15675
R5755 VSUB.n184 VSUB.n180 0.15675
R5756 VSUB.n185 VSUB.n184 0.15675
R5757 VSUB.n186 VSUB.n185 0.15675
R5758 VSUB.n188 VSUB.n186 0.15675
R5759 VSUB.n192 VSUB.n188 0.15675
R5760 VSUB.n193 VSUB.n192 0.15675
R5761 VSUB.n194 VSUB.n193 0.15675
R5762 VSUB.n195 VSUB.n194 0.15675
R5763 VSUB.n299 VSUB.n86 0.15675
R5764 VSUB.n295 VSUB.n86 0.15675
R5765 VSUB.n295 VSUB.n294 0.15675
R5766 VSUB.n294 VSUB.n293 0.15675
R5767 VSUB.n293 VSUB.n292 0.15675
R5768 VSUB.n292 VSUB.n93 0.15675
R5769 VSUB.n288 VSUB.n93 0.15675
R5770 VSUB.n288 VSUB.n287 0.15675
R5771 VSUB.n328 VSUB.n327 0.148756
R5772 VSUB.n329 VSUB.n328 0.148756
R5773 VSUB.n330 VSUB.n329 0.148756
R5774 VSUB.n331 VSUB.n330 0.148756
R5775 VSUB.n332 VSUB.n331 0.148756
R5776 VSUB.n333 VSUB.n332 0.148756
R5777 VSUB.n334 VSUB.n333 0.148756
R5778 VSUB.n67 VSUB.n59 0.148756
C0 vdd nu 3.65263f
C1 dw_12460_11350# ve 0.22765f
C2 ndl nsv 1.70844f
C3 nv dw_12460_11350# 7.5235f
C4 out vrefb 0.5218f
C5 ve nsv 0.08907f
C6 nv nsv 5.01193f
C7 dw_12460_11350# pbias 8.36783f
C8 nc2 out 1.01303f
C9 nb0 vrefb 0.35936f
C10 pbias nsv 3.52306f
C11 nb0 nc2 0.33783f
C12 dw_12460_11350# nsv 0.11023f
C13 vdd out 2.5388f
C14 nc2 vrefb 0.29475f
C15 nu ndl 1.42744f
C16 nb0 vdd 3.49431f
C17 ve nu 0.09015f
C18 nv nu 0.32344f
C19 vdd vrefb 4.74071f
C20 nu pbias 0.73327f
C21 nc2 vdd 4.28572f
C22 dw_12460_11350# nu 0.27986f
C23 out ndl 2.82482f
C24 nu nsv 0.37635f
C25 nv out 3.30809f
C26 vrefb ndl 1.78504f
C27 out pbias 2.60707f
C28 nb0 ve 0.67949f
C29 nb0 nv 0.20211f
C30 nv vrefb 0.80693f
C31 dw_12460_11350# out 1.01073f
C32 nc2 ndl 1.31943f
C33 nb0 pbias 1.01246f
C34 vrefb pbias 0.32791f
C35 out nsv 0.22111f
C36 nc2 ve 1.19769f
C37 nc2 nv 2.60147f
C38 nb0 dw_12460_11350# 0.05893f
C39 dw_12460_11350# vrefb 0.9208f
C40 nb0 nsv 0.33821f
C41 nc2 pbias 1.56347f
C42 vdd ndl 1.08181f
C43 vrefb nsv 0.12391f
C44 vdd ve 0.06f
C45 nc2 dw_12460_11350# 0.99705f
C46 vdd nv 11.6842f
C47 nc2 nsv 0.52138f
C48 vdd pbias 38.5945f
C49 out nu 0.2616f
C50 vdd dw_12460_11350# 10.534f
C51 vdd nsv 3.93973f
C52 nb0 nu 0.85451f
C53 vrefb nu 0.32713f
C54 nv ndl 0.40556f
C55 nc2 nu 5.31684f
C56 nv ve 0.24155f
C57 ndl pbias 0.56288f
C58 ve pbias 0.36974f
C59 dw_12460_11350# ndl 0.43057f
C60 nv pbias 9.5871f
C61 ve VSUB 4.08633f
C62 nu VSUB 7.07088f
C63 vrefb VSUB 4.60282f
C64 out VSUB 6.00692f
C65 nsv VSUB 13.55372f
C66 pbias VSUB 36.3935f
C67 ndl VSUB 12.00285f
C68 vdd VSUB 0.39684p
C69 nc2 VSUB 15.2768f
C70 nb0 VSUB 14.8695f
C71 dw_12460_11350# VSUB 25.1158f
C72 nv VSUB 17.20625f
C73 nv.t0 VSUB 0.78896f
C74 nv.t3 VSUB 0.71347f
C75 nv.n0 VSUB 3.53134f
C76 nv.t1 VSUB 70.74171f
C77 nv.n1 VSUB 1.53152f
C78 nv.n2 VSUB 0.01091f
C79 nv.n3 VSUB 0.01295f
C80 nv.n6 VSUB 0.01735f
C81 nv.n7 VSUB 0.01735f
C82 nv.n8 VSUB 0.07618f
C83 nv.n9 VSUB 0.07618f
C84 nv.n10 VSUB 0.01735f
C85 nv.n14 VSUB 0.01299f
C86 nv.n15 VSUB 0.01299f
C87 nv.n17 VSUB 0.01735f
C88 nv.n18 VSUB 0.06553f
C89 nv.n19 VSUB 0.01735f
C90 nv.n23 VSUB 0.01299f
C91 nv.n24 VSUB 0.01904f
C92 nv.n25 VSUB 0.01505f
C93 nv.n26 VSUB 0.01633f
C94 nv.n27 VSUB 0.01735f
C95 nv.n28 VSUB 0.07618f
C96 nv.n29 VSUB 0.01735f
C97 nv.n32 VSUB 0.01299f
C98 nv.n34 VSUB 0.01735f
C99 nv.n35 VSUB 0.07618f
C100 nv.n36 VSUB 0.01735f
C101 nv.n39 VSUB 0.01299f
C102 nv.n41 VSUB 0.01735f
C103 nv.n42 VSUB 0.07618f
C104 nv.n43 VSUB 0.01735f
C105 nv.n46 VSUB 0.01299f
C106 nv.n48 VSUB 0.01735f
C107 nv.n49 VSUB 0.07618f
C108 nv.n50 VSUB 0.01735f
C109 nv.n53 VSUB 0.01299f
C110 nv.n55 VSUB 0.01735f
C111 nv.n56 VSUB 0.06553f
C112 nv.n57 VSUB 0.02845f
C113 nv.n58 VSUB 0.02208f
C114 nv.n60 VSUB 0.01299f
C115 nv.n62 VSUB 0.18988f
C116 nv.n63 VSUB 0.01735f
C117 nv.n66 VSUB 0.07618f
C118 nv.n67 VSUB 0.01735f
C119 nv.n70 VSUB 0.01299f
C120 nv.n72 VSUB 0.01735f
C121 nv.n73 VSUB 0.07618f
C122 nv.n74 VSUB 0.01735f
C123 nv.n77 VSUB 0.01299f
C124 nv.n79 VSUB 0.01735f
C125 nv.n80 VSUB 0.07618f
C126 nv.n81 VSUB 0.01735f
C127 nv.n84 VSUB 0.01299f
C128 nv.n86 VSUB 0.01735f
C129 nv.n87 VSUB 0.06553f
C130 nv.n88 VSUB 0.01735f
C131 nv.n91 VSUB 0.01904f
C132 nv.n92 VSUB 0.02208f
C133 nv.n93 VSUB 0.01735f
C134 nv.n94 VSUB 0.01633f
C135 nv.n95 VSUB 0.07618f
C136 nv.n96 VSUB 0.01735f
C137 nv.n100 VSUB 0.01471f
C138 nv.n101 VSUB 0.01299f
C139 nv.n102 VSUB 0.01299f
C140 nv.n104 VSUB 0.01735f
C141 nv.n105 VSUB 0.07618f
C142 nv.n106 VSUB 0.01735f
C143 nv.n110 VSUB 0.01299f
C144 nv.n111 VSUB 0.01299f
C145 nv.n113 VSUB 0.01735f
C146 nv.n114 VSUB 0.07618f
C147 nv.n115 VSUB 0.01735f
C148 nv.n119 VSUB 0.01299f
C149 nv.n120 VSUB 0.01299f
C150 nv.n122 VSUB 0.01735f
C151 nv.n123 VSUB 0.07618f
C152 nv.n124 VSUB 0.01735f
C153 nv.n128 VSUB 0.01299f
C154 nv.n129 VSUB 0.01299f
C155 nv.n131 VSUB 0.01735f
C156 nv.n132 VSUB 0.06553f
C157 nv.n133 VSUB 0.02845f
C158 nv.n135 VSUB 0.01471f
C159 nv.n136 VSUB 0.01294f
C160 nv.n137 VSUB 0.01299f
C161 nv.n140 VSUB 0.01505f
C162 nv.n142 VSUB 0.18988f
C163 nv.n143 VSUB 0.01735f
C164 nv.n144 VSUB 0.01735f
C165 nv.n145 VSUB 0.07618f
C166 nv.n146 VSUB 0.01735f
C167 nv.n150 VSUB 0.01299f
C168 nv.n151 VSUB 0.01299f
C169 nv.n153 VSUB 0.01735f
C170 nv.n155 VSUB 0.01295f
C171 nv.n159 VSUB 0.01735f
C172 nv.n160 VSUB 0.07618f
C173 nv.n161 VSUB 0.07618f
C174 nv.n162 VSUB 0.07618f
C175 nv.n163 VSUB 0.01735f
C176 nv.n166 VSUB 0.01299f
C177 nv.n167 VSUB 0.01299f
C178 nv.n170 VSUB 0.01735f
C179 nv.n171 VSUB 0.07618f
C180 nv.n172 VSUB 0.07618f
C181 nv.n173 VSUB 0.05265f
C182 nv.n174 VSUB 0.01735f
C183 nv.n177 VSUB 0.01299f
C184 nv.n178 VSUB 0.01209f
C185 nv.n179 VSUB 0.01904f
C186 nv.n180 VSUB 0.02208f
C187 nv.n181 VSUB 0.01633f
C188 nv.n182 VSUB 0.02029f
C189 nv.n183 VSUB 0.0773f
C190 nv.n184 VSUB 0.07618f
C191 nv.n185 VSUB 0.07618f
C192 nv.n186 VSUB 0.01735f
C193 nv.n189 VSUB 0.01299f
C194 nv.n190 VSUB 0.01299f
C195 nv.n193 VSUB 0.01735f
C196 nv.n194 VSUB 0.07618f
C197 nv.n195 VSUB 0.07618f
C198 nv.n196 VSUB 0.07618f
C199 nv.n197 VSUB 0.01735f
C200 nv.n200 VSUB 0.01299f
C201 nv.n201 VSUB 0.01299f
C202 nv.n204 VSUB 0.01735f
C203 nv.n205 VSUB 0.07618f
C204 nv.n206 VSUB 0.07618f
C205 nv.n207 VSUB 0.07618f
C206 nv.n208 VSUB 0.01735f
C207 nv.n211 VSUB 0.01299f
C208 nv.n212 VSUB 0.01299f
C209 nv.n215 VSUB 0.01735f
C210 nv.n216 VSUB 0.07618f
C211 nv.n217 VSUB 0.07618f
C212 nv.n218 VSUB 0.07618f
C213 nv.n219 VSUB 0.01735f
C214 nv.n222 VSUB 0.01299f
C215 nv.n223 VSUB 0.01299f
C216 nv.n226 VSUB 0.01735f
C217 nv.n227 VSUB 0.07618f
C218 nv.n228 VSUB 0.07618f
C219 nv.n229 VSUB 0.0773f
C220 nv.n230 VSUB 0.02029f
C221 nv.n231 VSUB 0.02845f
C222 nv.n232 VSUB 0.18988f
C223 nv.n234 VSUB 0.01505f
C224 nv.n236 VSUB 0.01294f
C225 nv.n237 VSUB 0.01209f
C226 nv.n238 VSUB 0.01299f
C227 nv.n239 VSUB 0.01299f
C228 nv.n242 VSUB 0.01735f
C229 nv.n243 VSUB 0.05265f
C230 nv.n244 VSUB 0.07618f
C231 nv.n245 VSUB 0.07618f
C232 nv.n246 VSUB 0.01735f
C233 nv.n250 VSUB 0.01299f
C234 nv.n251 VSUB 0.01299f
C235 nv.n252 VSUB 0.01299f
C236 nv.n255 VSUB 0.01735f
C237 nv.n256 VSUB 0.07618f
C238 nv.n257 VSUB 0.07618f
C239 nv.n258 VSUB 0.07618f
C240 nv.n259 VSUB 0.01735f
C241 nv.n263 VSUB 0.01299f
C242 nv.n264 VSUB 0.01299f
C243 nv.n265 VSUB 0.01299f
C244 nv.n268 VSUB 0.01735f
C245 nv.n269 VSUB 0.07618f
C246 nv.n270 VSUB 0.07618f
C247 nv.n271 VSUB 0.07618f
C248 nv.n272 VSUB 0.01735f
C249 nv.n276 VSUB 0.01299f
C250 nv.n277 VSUB 0.01299f
C251 nv.n279 VSUB 0.01299f
C252 nv.n280 VSUB 0.01299f
C253 nv.n283 VSUB 0.01735f
C254 nv.n284 VSUB 0.07618f
C255 nv.n285 VSUB 0.07618f
C256 nv.n286 VSUB 0.05265f
C257 nv.n287 VSUB 0.01735f
C258 nv.n288 VSUB 0.01735f
C259 nv.n290 VSUB 0.01505f
C260 nv.n291 VSUB 0.01294f
C261 nv.n292 VSUB 0.01209f
C262 nv.n293 VSUB 0.01904f
C263 nv.n294 VSUB 0.01471f
C264 nv.n295 VSUB 0.01633f
C265 nv.n296 VSUB 0.02029f
C266 nv.n297 VSUB 0.0773f
C267 nv.n298 VSUB 0.07618f
C268 nv.n299 VSUB 0.07618f
C269 nv.n300 VSUB 0.01735f
C270 nv.n304 VSUB 0.01299f
C271 nv.n305 VSUB 0.01299f
C272 nv.n306 VSUB 0.01299f
C273 nv.n309 VSUB 0.01735f
C274 nv.n310 VSUB 0.07618f
C275 nv.n311 VSUB 0.07618f
C276 nv.n312 VSUB 0.07618f
C277 nv.n313 VSUB 0.01735f
C278 nv.n317 VSUB 0.01299f
C279 nv.n318 VSUB 0.01299f
C280 nv.n319 VSUB 0.01299f
C281 nv.n322 VSUB 0.01735f
C282 nv.n323 VSUB 0.07618f
C283 nv.n324 VSUB 0.07618f
C284 nv.n325 VSUB 0.07618f
C285 nv.n326 VSUB 0.01735f
C286 nv.n330 VSUB 0.01299f
C287 nv.n331 VSUB 0.01299f
C288 nv.n332 VSUB 0.01299f
C289 nv.n335 VSUB 0.01735f
C290 nv.n336 VSUB 0.07618f
C291 nv.n337 VSUB 0.07618f
C292 nv.n338 VSUB 0.07618f
C293 nv.n339 VSUB 0.01735f
C294 nv.n343 VSUB 0.01299f
C295 nv.n344 VSUB 0.01299f
C296 nv.n345 VSUB 0.01471f
C297 nv.n346 VSUB 0.01299f
C298 nv.n349 VSUB 0.01735f
C299 nv.n350 VSUB 0.07618f
C300 nv.n351 VSUB 0.07618f
C301 nv.n352 VSUB 0.0773f
C302 nv.n353 VSUB 0.02029f
C303 nv.n355 VSUB 0.18988f
C304 nv.n356 VSUB 0.02845f
C305 nv.n357 VSUB 0.02208f
C306 nv.n358 VSUB 0.01294f
C307 nv.n359 VSUB 0.01209f
C308 nv.n360 VSUB 0.01299f
C309 nv.n363 VSUB 0.01735f
C310 nv.n364 VSUB 0.05265f
C311 nv.n365 VSUB 0.07618f
C312 nv.n366 VSUB 0.07618f
C313 nv.n367 VSUB 0.01735f
C314 nv.n370 VSUB 0.01299f
C315 nv.n371 VSUB 0.01299f
C316 nv.n374 VSUB 0.01735f
C317 nv.n375 VSUB 0.07618f
C318 nv.n376 VSUB 0.07618f
C319 nv.n377 VSUB 0.07618f
C320 nv.n378 VSUB 0.01735f
C321 nv.n381 VSUB 0.01091f
C322 nv.n382 VSUB 0.34505f
C323 nv.t4 VSUB 3.51375f
C324 nv.t5 VSUB 3.51095f
C325 nv.n383 VSUB 2.95722f
C326 nv.n384 VSUB 1.61687f
C327 dw_12460_11350.t1 VSUB 0.59382f
C328 dw_12460_11350.t2 VSUB 0.24629f
C329 dw_12460_11350.n0 VSUB 1.58466f
C330 dw_12460_11350.t3 VSUB 62.1605f
C331 dw_12460_11350.n2 VSUB 0.01119f
C332 dw_12460_11350.n5 VSUB 0.01499f
C333 dw_12460_11350.n6 VSUB 0.01499f
C334 dw_12460_11350.n7 VSUB 0.0658f
C335 dw_12460_11350.n8 VSUB 0.0658f
C336 dw_12460_11350.n9 VSUB 0.01499f
C337 dw_12460_11350.n13 VSUB 0.01123f
C338 dw_12460_11350.n14 VSUB 0.01123f
C339 dw_12460_11350.n16 VSUB 0.01499f
C340 dw_12460_11350.n17 VSUB 0.05661f
C341 dw_12460_11350.n18 VSUB 0.01499f
C342 dw_12460_11350.n22 VSUB 0.01123f
C343 dw_12460_11350.n23 VSUB 0.01645f
C344 dw_12460_11350.n24 VSUB 0.013f
C345 dw_12460_11350.n25 VSUB 0.0141f
C346 dw_12460_11350.n26 VSUB 0.01499f
C347 dw_12460_11350.n27 VSUB 0.0658f
C348 dw_12460_11350.n28 VSUB 0.01499f
C349 dw_12460_11350.n31 VSUB 0.01123f
C350 dw_12460_11350.n33 VSUB 0.01499f
C351 dw_12460_11350.n34 VSUB 0.0658f
C352 dw_12460_11350.n35 VSUB 0.01499f
C353 dw_12460_11350.n38 VSUB 0.01123f
C354 dw_12460_11350.n40 VSUB 0.01499f
C355 dw_12460_11350.n41 VSUB 0.0658f
C356 dw_12460_11350.n42 VSUB 0.01499f
C357 dw_12460_11350.n45 VSUB 0.01123f
C358 dw_12460_11350.n47 VSUB 0.01499f
C359 dw_12460_11350.n48 VSUB 0.0658f
C360 dw_12460_11350.n49 VSUB 0.01499f
C361 dw_12460_11350.n52 VSUB 0.01123f
C362 dw_12460_11350.n54 VSUB 0.01499f
C363 dw_12460_11350.n55 VSUB 0.05661f
C364 dw_12460_11350.n56 VSUB 0.02458f
C365 dw_12460_11350.n57 VSUB 0.01907f
C366 dw_12460_11350.n59 VSUB 0.01123f
C367 dw_12460_11350.n61 VSUB 0.16403f
C368 dw_12460_11350.n62 VSUB 0.01499f
C369 dw_12460_11350.n65 VSUB 0.0658f
C370 dw_12460_11350.n66 VSUB 0.01499f
C371 dw_12460_11350.n69 VSUB 0.01123f
C372 dw_12460_11350.n71 VSUB 0.01499f
C373 dw_12460_11350.n72 VSUB 0.0658f
C374 dw_12460_11350.n73 VSUB 0.01499f
C375 dw_12460_11350.n76 VSUB 0.01123f
C376 dw_12460_11350.n78 VSUB 0.01499f
C377 dw_12460_11350.n79 VSUB 0.0658f
C378 dw_12460_11350.n80 VSUB 0.01499f
C379 dw_12460_11350.n83 VSUB 0.01123f
C380 dw_12460_11350.n85 VSUB 0.01499f
C381 dw_12460_11350.n86 VSUB 0.05661f
C382 dw_12460_11350.n87 VSUB 0.01499f
C383 dw_12460_11350.n90 VSUB 0.01645f
C384 dw_12460_11350.n91 VSUB 0.01907f
C385 dw_12460_11350.n92 VSUB 0.01499f
C386 dw_12460_11350.n93 VSUB 0.0141f
C387 dw_12460_11350.n94 VSUB 0.0658f
C388 dw_12460_11350.n95 VSUB 0.01499f
C389 dw_12460_11350.n99 VSUB 0.01271f
C390 dw_12460_11350.n100 VSUB 0.01123f
C391 dw_12460_11350.n101 VSUB 0.01123f
C392 dw_12460_11350.n103 VSUB 0.01499f
C393 dw_12460_11350.n104 VSUB 0.0658f
C394 dw_12460_11350.n105 VSUB 0.01499f
C395 dw_12460_11350.n109 VSUB 0.01123f
C396 dw_12460_11350.n110 VSUB 0.01123f
C397 dw_12460_11350.n112 VSUB 0.01499f
C398 dw_12460_11350.n113 VSUB 0.0658f
C399 dw_12460_11350.n114 VSUB 0.01499f
C400 dw_12460_11350.n118 VSUB 0.01123f
C401 dw_12460_11350.n119 VSUB 0.01123f
C402 dw_12460_11350.n121 VSUB 0.01499f
C403 dw_12460_11350.n122 VSUB 0.0658f
C404 dw_12460_11350.n123 VSUB 0.01499f
C405 dw_12460_11350.n127 VSUB 0.01123f
C406 dw_12460_11350.n128 VSUB 0.01123f
C407 dw_12460_11350.n130 VSUB 0.01499f
C408 dw_12460_11350.n131 VSUB 0.05661f
C409 dw_12460_11350.n132 VSUB 0.02458f
C410 dw_12460_11350.n134 VSUB 0.01271f
C411 dw_12460_11350.n135 VSUB 0.01118f
C412 dw_12460_11350.n136 VSUB 0.01123f
C413 dw_12460_11350.n139 VSUB 0.013f
C414 dw_12460_11350.n141 VSUB 0.16403f
C415 dw_12460_11350.n142 VSUB 0.01499f
C416 dw_12460_11350.n143 VSUB 0.01499f
C417 dw_12460_11350.n144 VSUB 0.0658f
C418 dw_12460_11350.n145 VSUB 0.01499f
C419 dw_12460_11350.n149 VSUB 0.01123f
C420 dw_12460_11350.n150 VSUB 0.01123f
C421 dw_12460_11350.n152 VSUB 0.01499f
C422 dw_12460_11350.n154 VSUB 0.01119f
C423 dw_12460_11350.n158 VSUB 0.01499f
C424 dw_12460_11350.n159 VSUB 0.0658f
C425 dw_12460_11350.n160 VSUB 0.0658f
C426 dw_12460_11350.n161 VSUB 0.0658f
C427 dw_12460_11350.n162 VSUB 0.01499f
C428 dw_12460_11350.n165 VSUB 0.01123f
C429 dw_12460_11350.n166 VSUB 0.01123f
C430 dw_12460_11350.n169 VSUB 0.01499f
C431 dw_12460_11350.n170 VSUB 0.0658f
C432 dw_12460_11350.n171 VSUB 0.0658f
C433 dw_12460_11350.n172 VSUB 0.04548f
C434 dw_12460_11350.n173 VSUB 0.01499f
C435 dw_12460_11350.n176 VSUB 0.01123f
C436 dw_12460_11350.n177 VSUB 0.01045f
C437 dw_12460_11350.n178 VSUB 0.01645f
C438 dw_12460_11350.n179 VSUB 0.01907f
C439 dw_12460_11350.n180 VSUB 0.0141f
C440 dw_12460_11350.n181 VSUB 0.01752f
C441 dw_12460_11350.n182 VSUB 0.06677f
C442 dw_12460_11350.n183 VSUB 0.0658f
C443 dw_12460_11350.n184 VSUB 0.0658f
C444 dw_12460_11350.n185 VSUB 0.01499f
C445 dw_12460_11350.n188 VSUB 0.01123f
C446 dw_12460_11350.n189 VSUB 0.01123f
C447 dw_12460_11350.n192 VSUB 0.01499f
C448 dw_12460_11350.n193 VSUB 0.0658f
C449 dw_12460_11350.n194 VSUB 0.0658f
C450 dw_12460_11350.n195 VSUB 0.0658f
C451 dw_12460_11350.n196 VSUB 0.01499f
C452 dw_12460_11350.n199 VSUB 0.01123f
C453 dw_12460_11350.n200 VSUB 0.01123f
C454 dw_12460_11350.n203 VSUB 0.01499f
C455 dw_12460_11350.n204 VSUB 0.0658f
C456 dw_12460_11350.n205 VSUB 0.0658f
C457 dw_12460_11350.n206 VSUB 0.0658f
C458 dw_12460_11350.n207 VSUB 0.01499f
C459 dw_12460_11350.n210 VSUB 0.01123f
C460 dw_12460_11350.n211 VSUB 0.01123f
C461 dw_12460_11350.n214 VSUB 0.01499f
C462 dw_12460_11350.n215 VSUB 0.0658f
C463 dw_12460_11350.n216 VSUB 0.0658f
C464 dw_12460_11350.n217 VSUB 0.0658f
C465 dw_12460_11350.n218 VSUB 0.01499f
C466 dw_12460_11350.n221 VSUB 0.01123f
C467 dw_12460_11350.n222 VSUB 0.01123f
C468 dw_12460_11350.n225 VSUB 0.01499f
C469 dw_12460_11350.n226 VSUB 0.0658f
C470 dw_12460_11350.n227 VSUB 0.0658f
C471 dw_12460_11350.n228 VSUB 0.06677f
C472 dw_12460_11350.n229 VSUB 0.01752f
C473 dw_12460_11350.n230 VSUB 0.02458f
C474 dw_12460_11350.n231 VSUB 0.16403f
C475 dw_12460_11350.n233 VSUB 0.013f
C476 dw_12460_11350.n235 VSUB 0.01118f
C477 dw_12460_11350.n236 VSUB 0.01045f
C478 dw_12460_11350.n237 VSUB 0.01123f
C479 dw_12460_11350.n238 VSUB 0.01123f
C480 dw_12460_11350.n241 VSUB 0.01499f
C481 dw_12460_11350.n242 VSUB 0.04548f
C482 dw_12460_11350.n243 VSUB 0.0658f
C483 dw_12460_11350.n244 VSUB 0.0658f
C484 dw_12460_11350.n245 VSUB 0.01499f
C485 dw_12460_11350.n249 VSUB 0.01123f
C486 dw_12460_11350.n250 VSUB 0.01123f
C487 dw_12460_11350.n251 VSUB 0.01123f
C488 dw_12460_11350.n254 VSUB 0.01499f
C489 dw_12460_11350.n255 VSUB 0.0658f
C490 dw_12460_11350.n256 VSUB 0.0658f
C491 dw_12460_11350.n257 VSUB 0.0658f
C492 dw_12460_11350.n258 VSUB 0.01499f
C493 dw_12460_11350.n262 VSUB 0.01123f
C494 dw_12460_11350.n263 VSUB 0.01123f
C495 dw_12460_11350.n264 VSUB 0.01123f
C496 dw_12460_11350.n267 VSUB 0.01499f
C497 dw_12460_11350.n268 VSUB 0.0658f
C498 dw_12460_11350.n269 VSUB 0.0658f
C499 dw_12460_11350.n270 VSUB 0.0658f
C500 dw_12460_11350.n271 VSUB 0.01499f
C501 dw_12460_11350.n275 VSUB 0.01123f
C502 dw_12460_11350.n276 VSUB 0.01123f
C503 dw_12460_11350.n278 VSUB 0.01123f
C504 dw_12460_11350.n279 VSUB 0.01123f
C505 dw_12460_11350.n282 VSUB 0.01499f
C506 dw_12460_11350.n283 VSUB 0.0658f
C507 dw_12460_11350.n284 VSUB 0.0658f
C508 dw_12460_11350.n285 VSUB 0.04548f
C509 dw_12460_11350.n286 VSUB 0.01499f
C510 dw_12460_11350.n287 VSUB 0.01499f
C511 dw_12460_11350.n289 VSUB 0.013f
C512 dw_12460_11350.n290 VSUB 0.01118f
C513 dw_12460_11350.n291 VSUB 0.01045f
C514 dw_12460_11350.n292 VSUB 0.01645f
C515 dw_12460_11350.n293 VSUB 0.01271f
C516 dw_12460_11350.n294 VSUB 0.0141f
C517 dw_12460_11350.n295 VSUB 0.01752f
C518 dw_12460_11350.n296 VSUB 0.06677f
C519 dw_12460_11350.n297 VSUB 0.0658f
C520 dw_12460_11350.n298 VSUB 0.0658f
C521 dw_12460_11350.n299 VSUB 0.01499f
C522 dw_12460_11350.n303 VSUB 0.01123f
C523 dw_12460_11350.n304 VSUB 0.01123f
C524 dw_12460_11350.n305 VSUB 0.01123f
C525 dw_12460_11350.n308 VSUB 0.01499f
C526 dw_12460_11350.n309 VSUB 0.0658f
C527 dw_12460_11350.n310 VSUB 0.0658f
C528 dw_12460_11350.n311 VSUB 0.0658f
C529 dw_12460_11350.n312 VSUB 0.01499f
C530 dw_12460_11350.n316 VSUB 0.01123f
C531 dw_12460_11350.n317 VSUB 0.01123f
C532 dw_12460_11350.n318 VSUB 0.01123f
C533 dw_12460_11350.n321 VSUB 0.01499f
C534 dw_12460_11350.n322 VSUB 0.0658f
C535 dw_12460_11350.n323 VSUB 0.0658f
C536 dw_12460_11350.n324 VSUB 0.0658f
C537 dw_12460_11350.n325 VSUB 0.01499f
C538 dw_12460_11350.n329 VSUB 0.01123f
C539 dw_12460_11350.n330 VSUB 0.01123f
C540 dw_12460_11350.n331 VSUB 0.01123f
C541 dw_12460_11350.n334 VSUB 0.01499f
C542 dw_12460_11350.n335 VSUB 0.0658f
C543 dw_12460_11350.n336 VSUB 0.0658f
C544 dw_12460_11350.n337 VSUB 0.0658f
C545 dw_12460_11350.n338 VSUB 0.01499f
C546 dw_12460_11350.n342 VSUB 0.01123f
C547 dw_12460_11350.n343 VSUB 0.01123f
C548 dw_12460_11350.n344 VSUB 0.01271f
C549 dw_12460_11350.n345 VSUB 0.01123f
C550 dw_12460_11350.n348 VSUB 0.01499f
C551 dw_12460_11350.n349 VSUB 0.0658f
C552 dw_12460_11350.n350 VSUB 0.0658f
C553 dw_12460_11350.n351 VSUB 0.06677f
C554 dw_12460_11350.n352 VSUB 0.01752f
C555 dw_12460_11350.n354 VSUB 0.16403f
C556 dw_12460_11350.n355 VSUB 0.02458f
C557 dw_12460_11350.n356 VSUB 0.01907f
C558 dw_12460_11350.n357 VSUB 0.01118f
C559 dw_12460_11350.n358 VSUB 0.01045f
C560 dw_12460_11350.n359 VSUB 0.01123f
C561 dw_12460_11350.n362 VSUB 0.01499f
C562 dw_12460_11350.n363 VSUB 0.04548f
C563 dw_12460_11350.n364 VSUB 0.0658f
C564 dw_12460_11350.n365 VSUB 0.0658f
C565 dw_12460_11350.n366 VSUB 0.01499f
C566 dw_12460_11350.n369 VSUB 0.01123f
C567 dw_12460_11350.n370 VSUB 0.01123f
C568 dw_12460_11350.n373 VSUB 0.01499f
C569 dw_12460_11350.n374 VSUB 0.0658f
C570 dw_12460_11350.n375 VSUB 0.0658f
C571 dw_12460_11350.n376 VSUB 0.0658f
C572 dw_12460_11350.n377 VSUB 0.01499f
C573 dw_12460_11350.n381 VSUB 0.4235f
C574 dw_12460_11350.t5 VSUB 3.03531f
C575 dw_12460_11350.t6 VSUB 3.03289f
C576 dw_12460_11350.n382 VSUB 1.98476f
C577 dw_12460_11350.n383 VSUB 1.57963f
C578 dw_12460_11350.n384 VSUB 1.12041f
C579 dw_12460_11350.n385 VSUB 2.07472f
C580 dw_12460_11350.t0 VSUB 0.78905f
C581 nb0.t1 VSUB 13.2015f
C582 nb0.n0 VSUB 4.4005f
C583 nc2.t1 VSUB 17.8779f
C584 nc2.n0 VSUB 5.95929f
C585 vdd.t17 VSUB 0.01988f
C586 vdd.n7 VSUB 0.05132f
C587 vdd.n9 VSUB 0.02573f
C588 vdd.n10 VSUB 0.01712f
C589 vdd.t26 VSUB 0.06445f
C590 vdd.n15 VSUB 0.13942f
C591 vdd.n16 VSUB 0.01876f
C592 vdd.n18 VSUB 0.01958f
C593 vdd.n21 VSUB 0.03152f
C594 vdd.n67 VSUB 0.8431f
C595 vdd.n68 VSUB 0.81299f
C596 vdd.n69 VSUB 0.01876f
C597 vdd.n186 VSUB 1.3664f
C598 vdd.n188 VSUB 0.01644f
C599 vdd.n189 VSUB 0.55632f
C600 vdd.n190 VSUB 0.01353f
C601 vdd.n191 VSUB 0.01628f
C602 vdd.n192 VSUB 0.27886f
C603 vdd.n195 VSUB 0.27886f
C604 vdd.n198 VSUB 0.27886f
C605 vdd.n201 VSUB 0.27886f
C606 vdd.n204 VSUB 0.27886f
C607 vdd.n207 VSUB 0.27886f
C608 vdd.n210 VSUB 0.20914f
C609 vdd.n213 VSUB 0.20914f
C610 vdd.n216 VSUB 0.27886f
C611 vdd.n219 VSUB 0.27886f
C612 vdd.n222 VSUB 0.27886f
C613 vdd.n225 VSUB 0.27886f
C614 vdd.n228 VSUB 1.03681f
C615 vdd.n231 VSUB 0.34577f
C616 vdd.n315 VSUB 1.3664f
C617 vdd.n317 VSUB 0.01644f
C618 vdd.n318 VSUB 0.55632f
C619 vdd.n319 VSUB 0.01353f
C620 vdd.n320 VSUB 0.01628f
C621 vdd.n321 VSUB 0.27886f
C622 vdd.n324 VSUB 0.27886f
C623 vdd.n327 VSUB 0.27886f
C624 vdd.n330 VSUB 0.27886f
C625 vdd.n333 VSUB 0.27886f
C626 vdd.n336 VSUB 0.27886f
C627 vdd.n339 VSUB 0.20914f
C628 vdd.n342 VSUB 0.20914f
C629 vdd.n345 VSUB 0.27886f
C630 vdd.n348 VSUB 0.27886f
C631 vdd.n351 VSUB 0.27886f
C632 vdd.n354 VSUB 0.27886f
C633 vdd.n357 VSUB 0.27886f
C634 vdd.n360 VSUB 0.27886f
C635 vdd.n363 VSUB 1.08894f
C636 vdd.n364 VSUB 0.01233f
C637 vdd.n365 VSUB 0.488f
C638 vdd.n366 VSUB 0.01201f
C639 vdd.n367 VSUB 0.01632f
C640 vdd.n368 VSUB 0.27886f
C641 vdd.n370 VSUB 0.27886f
C642 vdd.n373 VSUB 0.27886f
C643 vdd.n376 VSUB 0.27886f
C644 vdd.n379 VSUB 0.27886f
C645 vdd.n382 VSUB 0.27886f
C646 vdd.n385 VSUB 0.20914f
C647 vdd.n388 VSUB 0.20914f
C648 vdd.n391 VSUB 0.27886f
C649 vdd.n394 VSUB 0.27886f
C650 vdd.n397 VSUB 0.27886f
C651 vdd.n400 VSUB 0.27886f
C652 vdd.n403 VSUB 0.27886f
C653 vdd.n406 VSUB 0.27886f
C654 vdd.n409 VSUB 1.08894f
C655 vdd.n410 VSUB 0.01233f
C656 vdd.n411 VSUB 0.16695f
C657 vdd.n414 VSUB 0.15096f
C658 vdd.n417 VSUB 0.06526f
C659 vdd.n420 VSUB 0.06526f
C660 vdd.n423 VSUB 0.06526f
C661 vdd.n426 VSUB 0.06526f
C662 vdd.n429 VSUB 0.04895f
C663 vdd.n432 VSUB 0.04895f
C664 vdd.n435 VSUB 0.06526f
C665 vdd.n438 VSUB 0.06526f
C666 vdd.n441 VSUB 0.06526f
C667 vdd.n444 VSUB 0.06526f
C668 vdd.n447 VSUB 0.15096f
C669 vdd.n450 VSUB 0.16641f
C670 vdd.n453 VSUB 0.03728f
C671 vdd.n454 VSUB 0.03786f
C672 vdd.n455 VSUB 0.03152f
C673 vdd.n468 VSUB 0.02573f
C674 vdd.n470 VSUB 0.01318f
C675 vdd.n503 VSUB 0.10264f
C676 vdd.t15 VSUB 0.03975f
C677 vdd.t18 VSUB 0.13129f
C678 vdd.n505 VSUB 0.23537f
C679 vdd.n507 VSUB 0.01712f
C680 vdd.n508 VSUB 0.03152f
C681 vdd.t11 VSUB 0.28353f
C682 vdd.n522 VSUB 0.58169f
C683 vdd.n523 VSUB 0.04115f
C684 vdd.n524 VSUB 0.03152f
C685 vdd.n570 VSUB 0.02337f
C686 vdd.n572 VSUB 0.02056f
C687 vdd.n573 VSUB 0.01575f
C688 vdd.t13 VSUB 0.28353f
C689 vdd.n574 VSUB 0.56012f
C690 vdd.n575 VSUB 0.01712f
C691 vdd.n576 VSUB 0.03152f
C692 vdd.n622 VSUB 0.02337f
C693 vdd.n624 VSUB 0.02056f
C694 vdd.n625 VSUB 0.01583f
C695 vdd.n626 VSUB 0.47581f
C696 vdd.n627 VSUB 0.212f
C697 vdd.n629 VSUB 0.01958f
C698 vdd.n630 VSUB 0.03152f
C699 vdd.n644 VSUB 0.26202f
C700 vdd.n645 VSUB 0.14776f
C701 vdd.n646 VSUB 0.01876f
C702 vdd.n648 VSUB 0.01958f
C703 vdd.n655 VSUB 0.399f
C704 vdd.n656 VSUB 0.73571f
C705 vdd.n657 VSUB 0.01876f
C706 vdd.n665 VSUB 0.01958f
C707 vdd.t5 VSUB 0.13129f
C708 vdd.n666 VSUB 0.02573f
C709 vdd.n668 VSUB 0.01318f
C710 vdd.n701 VSUB 0.10264f
C711 vdd.t3 VSUB 0.03975f
C712 vdd.n703 VSUB 0.23545f
C713 vdd.n704 VSUB 0.03152f
C714 vdd.t2 VSUB 0.73571f
C715 vdd.t4 VSUB 0.88255f
C716 vdd.n705 VSUB 0.03152f
C717 vdd.n706 VSUB 0.48436f
C718 vdd.t22 VSUB 0.47967f
C719 vdd.n707 VSUB 0.52297f
C720 vdd.n708 VSUB 0.01032f
C721 vdd.n775 VSUB 0.02031f
C722 vdd.n777 VSUB 0.01649f
C723 vdd.n778 VSUB 0.18059f
C724 vdd.n780 VSUB 0.18059f
C725 vdd.n782 VSUB 0.18059f
C726 vdd.n784 VSUB 0.17156f
C727 vdd.n786 VSUB 0.35215f
C728 vdd.n788 VSUB 0.36118f
C729 vdd.n790 VSUB 0.36118f
C730 vdd.n792 VSUB 0.25283f
C731 vdd.n794 VSUB 0.16253f
C732 vdd.n796 VSUB 0.18059f
C733 vdd.n798 VSUB 0.18059f
C734 vdd.n800 VSUB 0.18059f
C735 vdd.n802 VSUB 0.18059f
C736 vdd.n804 VSUB 0.18059f
C737 vdd.n806 VSUB 0.18059f
C738 vdd.n808 VSUB 0.16253f
C739 vdd.n810 VSUB 0.28894f
C740 vdd.n812 VSUB 0.36118f
C741 vdd.n814 VSUB 0.36118f
C742 vdd.n816 VSUB 0.33409f
C743 vdd.n818 VSUB 0.1535f
C744 vdd.n820 VSUB 0.18059f
C745 vdd.n822 VSUB 0.18059f
C746 vdd.n824 VSUB 0.18059f
C747 vdd.n826 VSUB 0.18059f
C748 vdd.n828 VSUB 0.18059f
C749 vdd.n830 VSUB 0.18059f
C750 vdd.n832 VSUB 0.18059f
C751 vdd.n834 VSUB 0.18059f
C752 vdd.n836 VSUB 0.17156f
C753 vdd.n838 VSUB 0.18059f
C754 vdd.n840 VSUB 0.18059f
C755 vdd.n842 VSUB 0.18059f
C756 vdd.n844 VSUB 0.18059f
C757 vdd.n846 VSUB 1.01593f
C758 vdd.n847 VSUB 0.01247f
C759 vdd.n848 VSUB 0.18059f
C760 vdd.n851 VSUB 0.18059f
C761 vdd.n854 VSUB 0.01806f
C762 vdd.n857 VSUB 0.18059f
C763 vdd.n858 VSUB 0.02007f
C764 vdd.n859 VSUB 0.01063f
C765 vdd.n860 VSUB 0.01063f
C766 vdd.n861 VSUB 0.03525f
C767 vdd.n862 VSUB 0.18059f
C768 vdd.n863 VSUB 0.02007f
C769 vdd.n864 VSUB 0.12641f
C770 vdd.n867 VSUB 0.18059f
C771 vdd.n870 VSUB 0.18059f
C772 vdd.n873 VSUB 0.18059f
C773 vdd.n876 VSUB 0.18059f
C774 vdd.n879 VSUB 0.18059f
C775 vdd.n882 VSUB 0.09029f
C776 vdd.n885 VSUB 0.18059f
C777 vdd.n886 VSUB 0.02045f
C778 vdd.n887 VSUB 0.01094f
C779 vdd.n888 VSUB 0.01094f
C780 vdd.n889 VSUB 0.02086f
C781 vdd.n893 VSUB 0.02086f
C782 vdd.n894 VSUB 0.18059f
C783 vdd.n895 VSUB 0.02045f
C784 vdd.n896 VSUB 0.05418f
C785 vdd.n899 VSUB 0.18059f
C786 vdd.n902 VSUB 0.18059f
C787 vdd.n905 VSUB 0.18059f
C788 vdd.n908 VSUB 0.18059f
C789 vdd.n911 VSUB 0.18059f
C790 vdd.n914 VSUB 0.18059f
C791 vdd.n917 VSUB 0.18059f
C792 vdd.n920 VSUB 0.16253f
C793 vdd.n923 VSUB 0.18059f
C794 vdd.n926 VSUB 0.18059f
C795 vdd.n929 VSUB 0.18059f
C796 vdd.n932 VSUB 0.18059f
C797 vdd.n935 VSUB 1.02504f
C798 vdd.n936 VSUB 0.01322f
C799 vdd.n937 VSUB 0.01125f
C800 vdd.n938 VSUB 0.01125f
C801 vdd.n939 VSUB 0.02114f
C802 vdd.n949 VSUB 0.02114f
C803 vdd.t21 VSUB 0.02709f
C804 vdd.t1 VSUB 0.1535f
C805 vdd.t9 VSUB 0.10835f
C806 vdd.t33 VSUB 0.07224f
C807 vdd.t34 VSUB 0.17156f
C808 vdd.n950 VSUB 0.02522f
C809 vdd.t24 VSUB 0.47967f
C810 vdd.n951 VSUB 0.48605f
C811 vdd.n952 VSUB 0.01032f
C812 vdd.n1019 VSUB 0.02031f
C813 vdd.n1021 VSUB 0.01649f
C814 vdd.n1022 VSUB 0.18059f
C815 vdd.n1024 VSUB 0.18059f
C816 vdd.n1026 VSUB 0.18059f
C817 vdd.n1028 VSUB 0.17156f
C818 vdd.n1030 VSUB 0.35215f
C819 vdd.n1032 VSUB 0.36118f
C820 vdd.n1034 VSUB 0.36118f
C821 vdd.n1036 VSUB 0.25283f
C822 vdd.n1038 VSUB 0.16253f
C823 vdd.n1040 VSUB 0.18059f
C824 vdd.n1042 VSUB 0.18059f
C825 vdd.n1044 VSUB 0.18059f
C826 vdd.n1046 VSUB 0.18059f
C827 vdd.n1048 VSUB 0.18059f
C828 vdd.n1050 VSUB 0.18059f
C829 vdd.n1052 VSUB 0.16253f
C830 vdd.n1054 VSUB 0.28894f
C831 vdd.n1056 VSUB 0.36118f
C832 vdd.n1058 VSUB 0.36118f
C833 vdd.n1060 VSUB 0.33409f
C834 vdd.n1062 VSUB 0.1535f
C835 vdd.n1064 VSUB 0.18059f
C836 vdd.n1066 VSUB 0.18059f
C837 vdd.n1068 VSUB 0.18059f
C838 vdd.n1070 VSUB 0.18059f
C839 vdd.n1072 VSUB 0.18059f
C840 vdd.n1074 VSUB 0.18059f
C841 vdd.n1076 VSUB 0.18059f
C842 vdd.n1078 VSUB 0.18059f
C843 vdd.n1080 VSUB 0.17156f
C844 vdd.n1082 VSUB 0.18059f
C845 vdd.n1084 VSUB 0.18059f
C846 vdd.n1086 VSUB 0.18059f
C847 vdd.n1088 VSUB 0.18059f
C848 vdd.n1090 VSUB 1.01593f
C849 vdd.n1091 VSUB 0.01247f
C850 vdd.n1092 VSUB 0.18059f
C851 vdd.n1095 VSUB 0.18059f
C852 vdd.n1098 VSUB 0.01806f
C853 vdd.n1101 VSUB 0.18059f
C854 vdd.n1102 VSUB 0.02007f
C855 vdd.n1103 VSUB 0.01063f
C856 vdd.n1104 VSUB 0.01063f
C857 vdd.n1105 VSUB 0.03525f
C858 vdd.n1106 VSUB 0.18059f
C859 vdd.n1107 VSUB 0.02007f
C860 vdd.n1108 VSUB 0.12641f
C861 vdd.n1111 VSUB 0.18059f
C862 vdd.n1114 VSUB 0.18059f
C863 vdd.n1117 VSUB 0.18059f
C864 vdd.n1120 VSUB 0.18059f
C865 vdd.n1123 VSUB 0.18059f
C866 vdd.n1126 VSUB 0.09029f
C867 vdd.n1129 VSUB 0.18059f
C868 vdd.n1130 VSUB 0.02045f
C869 vdd.n1131 VSUB 0.01094f
C870 vdd.n1132 VSUB 0.01094f
C871 vdd.n1133 VSUB 0.02086f
C872 vdd.n1137 VSUB 0.02086f
C873 vdd.n1138 VSUB 0.18059f
C874 vdd.n1139 VSUB 0.02045f
C875 vdd.n1140 VSUB 0.05418f
C876 vdd.n1143 VSUB 0.18059f
C877 vdd.n1146 VSUB 0.18059f
C878 vdd.n1149 VSUB 0.18059f
C879 vdd.n1152 VSUB 0.18059f
C880 vdd.n1155 VSUB 0.18059f
C881 vdd.n1158 VSUB 0.18059f
C882 vdd.n1161 VSUB 0.18059f
C883 vdd.n1164 VSUB 0.16253f
C884 vdd.n1167 VSUB 0.18059f
C885 vdd.n1170 VSUB 0.18059f
C886 vdd.n1173 VSUB 0.18059f
C887 vdd.n1176 VSUB 0.18059f
C888 vdd.n1179 VSUB 1.02504f
C889 vdd.n1180 VSUB 0.01322f
C890 vdd.n1181 VSUB 0.01125f
C891 vdd.n1182 VSUB 0.01125f
C892 vdd.n1183 VSUB 0.02114f
C893 vdd.n1193 VSUB 0.02114f
C894 vdd.t23 VSUB 0.02709f
C895 vdd.t0 VSUB 0.1535f
C896 vdd.t8 VSUB 0.10835f
C897 vdd.t35 VSUB 0.07224f
C898 vdd.t36 VSUB 0.17156f
C899 vdd.n1194 VSUB 0.02522f
C900 vdd.n1195 VSUB 0.98f
C901 vdd.n1196 VSUB 1.70861f
C902 vdd.n1197 VSUB 0.31996f
C903 vdd.t20 VSUB 0.13053f
C904 vdd.t28 VSUB 0.13053f
C905 vdd.n1198 VSUB 0.59738f
C906 vdd.n1199 VSUB 0.012f
C907 vdd.n1200 VSUB 0.012f
C908 vdd.n1203 VSUB 0.0218f
C909 vdd.n1279 VSUB 0.0218f
C910 vdd.n1281 VSUB 1.19632f
C911 vdd.n1282 VSUB 0.01819f
C912 vdd.n1283 VSUB 0.35657f
C913 vdd.n1285 VSUB 0.33319f
C914 vdd.n1287 VSUB 0.21303f
C915 vdd.n1289 VSUB 0.20028f
C916 vdd.n1291 VSUB 0.34594f
C917 vdd.n1293 VSUB 0.36415f
C918 vdd.n1295 VSUB 0.36415f
C919 vdd.n1297 VSUB 0.20574f
C920 vdd.n1299 VSUB 0.16387f
C921 vdd.n1301 VSUB 0.18207f
C922 vdd.n1303 VSUB 0.18207f
C923 vdd.n1305 VSUB 0.18207f
C924 vdd.n1307 VSUB 0.18207f
C925 vdd.n1309 VSUB 0.18207f
C926 vdd.n1311 VSUB 0.18207f
C927 vdd.n1313 VSUB 0.16387f
C928 vdd.n1315 VSUB 0.34048f
C929 vdd.n1317 VSUB 0.36415f
C930 vdd.n1319 VSUB 0.36415f
C931 vdd.n1321 VSUB 0.2458f
C932 vdd.n1323 VSUB 0.18207f
C933 vdd.n1325 VSUB 0.16751f
C934 vdd.n1327 VSUB 0.18207f
C935 vdd.n1329 VSUB 0.18207f
C936 vdd.n1331 VSUB 0.18207f
C937 vdd.n1333 VSUB 0.18207f
C938 vdd.n1335 VSUB 0.18207f
C939 vdd.n1337 VSUB 0.18207f
C940 vdd.n1339 VSUB 0.18207f
C941 vdd.n1341 VSUB 0.13109f
C942 vdd.n1343 VSUB 0.18207f
C943 vdd.n1345 VSUB 0.18207f
C944 vdd.n1347 VSUB 0.18207f
C945 vdd.n1349 VSUB 0.18207f
C946 vdd.n1351 VSUB 0.18207f
C947 vdd.n1353 VSUB 0.18207f
C948 vdd.n1355 VSUB 0.18207f
C949 vdd.n1357 VSUB 0.18207f
C950 vdd.n1359 VSUB 0.15476f
C951 vdd.n1361 VSUB 0.18207f
C952 vdd.n1363 VSUB 0.18207f
C953 vdd.n1365 VSUB 0.18207f
C954 vdd.n1366 VSUB 0.05657f
C955 vdd.n1367 VSUB 0.18207f
C956 vdd.n1368 VSUB 0.01889f
C957 vdd.n1369 VSUB 0.17661f
C958 vdd.n1372 VSUB 0.18207f
C959 vdd.n1375 VSUB 0.18207f
C960 vdd.n1378 VSUB 0.18207f
C961 vdd.n1381 VSUB 0.18207f
C962 vdd.n1384 VSUB 0.18207f
C963 vdd.n1387 VSUB 0.04188f
C964 vdd.n1390 VSUB 0.18207f
C965 vdd.n1391 VSUB 0.01959f
C966 vdd.n1392 VSUB 0.01094f
C967 vdd.n1393 VSUB 0.01094f
C968 vdd.n1394 VSUB 0.02086f
C969 vdd.n1398 VSUB 0.02086f
C970 vdd.n1399 VSUB 0.18207f
C971 vdd.n1400 VSUB 0.01957f
C972 vdd.n1401 VSUB 0.07829f
C973 vdd.n1404 VSUB 0.18207f
C974 vdd.n1407 VSUB 0.18207f
C975 vdd.n1410 VSUB 0.18207f
C976 vdd.n1413 VSUB 0.18207f
C977 vdd.n1416 VSUB 0.18207f
C978 vdd.n1419 VSUB 0.18207f
C979 vdd.n1422 VSUB 0.18207f
C980 vdd.n1425 VSUB 0.11471f
C981 vdd.n1428 VSUB 0.18207f
C982 vdd.n1431 VSUB 0.18207f
C983 vdd.n1434 VSUB 0.18207f
C984 vdd.n1437 VSUB 0.18207f
C985 vdd.n1440 VSUB 0.18207f
C986 vdd.n1443 VSUB 0.18207f
C987 vdd.n1446 VSUB 0.18207f
C988 vdd.n1449 VSUB 0.18207f
C989 vdd.n1452 VSUB 0.09104f
C990 vdd.n1455 VSUB 0.18207f
C991 vdd.n1458 VSUB 0.18207f
C992 vdd.n1461 VSUB 0.18207f
C993 vdd.n1464 VSUB 0.04228f
C994 vdd.n1467 VSUB 0.01987f
C995 vdd.n1485 VSUB 0.01987f
C996 vdd.t19 VSUB 0.11835f
C997 vdd.t27 VSUB 0.11835f
C998 vdd.t31 VSUB 0.11835f
C999 vdd.t32 VSUB 0.1584f
C1000 vdd.t39 VSUB 0.02367f
C1001 vdd.t40 VSUB 0.18207f
C1002 vdd.n1486 VSUB 1.02341f
C1003 vdd.n1487 VSUB 0.01413f
C1004 vdd.t30 VSUB 0.47967f
C1005 vdd.n1488 VSUB 0.52727f
C1006 vdd.n1489 VSUB 0.01032f
C1007 vdd.n1556 VSUB 0.02031f
C1008 vdd.n1558 VSUB 0.01649f
C1009 vdd.n1559 VSUB 0.18059f
C1010 vdd.n1561 VSUB 0.18059f
C1011 vdd.n1563 VSUB 0.18059f
C1012 vdd.n1565 VSUB 0.17156f
C1013 vdd.n1567 VSUB 0.35215f
C1014 vdd.n1569 VSUB 0.36118f
C1015 vdd.n1571 VSUB 0.36118f
C1016 vdd.n1573 VSUB 0.25283f
C1017 vdd.n1575 VSUB 0.16253f
C1018 vdd.n1577 VSUB 0.18059f
C1019 vdd.n1579 VSUB 0.18059f
C1020 vdd.n1581 VSUB 0.18059f
C1021 vdd.n1583 VSUB 0.18059f
C1022 vdd.n1585 VSUB 0.18059f
C1023 vdd.n1587 VSUB 0.18059f
C1024 vdd.n1589 VSUB 0.16253f
C1025 vdd.n1591 VSUB 0.28894f
C1026 vdd.n1593 VSUB 0.36118f
C1027 vdd.n1595 VSUB 0.36118f
C1028 vdd.n1597 VSUB 0.33409f
C1029 vdd.n1599 VSUB 0.1535f
C1030 vdd.n1601 VSUB 0.18059f
C1031 vdd.n1603 VSUB 0.18059f
C1032 vdd.n1605 VSUB 0.18059f
C1033 vdd.n1607 VSUB 0.18059f
C1034 vdd.n1609 VSUB 0.18059f
C1035 vdd.n1611 VSUB 0.18059f
C1036 vdd.n1613 VSUB 0.18059f
C1037 vdd.n1615 VSUB 0.18059f
C1038 vdd.n1617 VSUB 0.17156f
C1039 vdd.n1619 VSUB 0.18059f
C1040 vdd.n1621 VSUB 0.18059f
C1041 vdd.n1623 VSUB 0.18059f
C1042 vdd.n1625 VSUB 0.18059f
C1043 vdd.n1627 VSUB 1.01593f
C1044 vdd.n1628 VSUB 0.01247f
C1045 vdd.n1629 VSUB 0.18059f
C1046 vdd.n1632 VSUB 0.18059f
C1047 vdd.n1635 VSUB 0.01806f
C1048 vdd.n1638 VSUB 0.18059f
C1049 vdd.n1639 VSUB 0.02007f
C1050 vdd.n1640 VSUB 0.01063f
C1051 vdd.n1641 VSUB 0.01063f
C1052 vdd.n1642 VSUB 0.03525f
C1053 vdd.n1643 VSUB 0.18059f
C1054 vdd.n1644 VSUB 0.02007f
C1055 vdd.n1645 VSUB 0.12641f
C1056 vdd.n1648 VSUB 0.18059f
C1057 vdd.n1651 VSUB 0.18059f
C1058 vdd.n1654 VSUB 0.18059f
C1059 vdd.n1657 VSUB 0.18059f
C1060 vdd.n1660 VSUB 0.18059f
C1061 vdd.n1663 VSUB 0.09029f
C1062 vdd.n1666 VSUB 0.18059f
C1063 vdd.n1667 VSUB 0.02045f
C1064 vdd.n1668 VSUB 0.01094f
C1065 vdd.n1669 VSUB 0.01094f
C1066 vdd.n1670 VSUB 0.02086f
C1067 vdd.n1674 VSUB 0.02086f
C1068 vdd.n1675 VSUB 0.18059f
C1069 vdd.n1676 VSUB 0.02045f
C1070 vdd.n1677 VSUB 0.05418f
C1071 vdd.n1680 VSUB 0.18059f
C1072 vdd.n1683 VSUB 0.18059f
C1073 vdd.n1686 VSUB 0.18059f
C1074 vdd.n1689 VSUB 0.18059f
C1075 vdd.n1692 VSUB 0.18059f
C1076 vdd.n1695 VSUB 0.18059f
C1077 vdd.n1698 VSUB 0.18059f
C1078 vdd.n1701 VSUB 0.16253f
C1079 vdd.n1704 VSUB 0.18059f
C1080 vdd.n1707 VSUB 0.18059f
C1081 vdd.n1710 VSUB 0.18059f
C1082 vdd.n1713 VSUB 0.18059f
C1083 vdd.n1716 VSUB 1.02504f
C1084 vdd.n1717 VSUB 0.01322f
C1085 vdd.n1718 VSUB 0.01125f
C1086 vdd.n1719 VSUB 0.01125f
C1087 vdd.n1720 VSUB 0.02114f
C1088 vdd.n1730 VSUB 0.02114f
C1089 vdd.t29 VSUB 0.02709f
C1090 vdd.t6 VSUB 0.1535f
C1091 vdd.t7 VSUB 0.10835f
C1092 vdd.t37 VSUB 0.07224f
C1093 vdd.t38 VSUB 0.17156f
C1094 vdd.n1731 VSUB 0.02522f
C1095 vdd.n1732 VSUB 1.43442f
C1096 vdd.n1733 VSUB 0.2076f
C1097 vdd.n1734 VSUB 0.14768f
C1098 vdd.t14 VSUB 0.17206f
C1099 vdd.t10 VSUB 0.13943f
C1100 vdd.t12 VSUB 0.13943f
C1101 vdd.n1736 VSUB 1.19597f
C1102 vdd.t16 VSUB 1.20013f
C1103 vdd.t25 VSUB 1.52704f
C1104 w_9880_11630.t3 VSUB 0.29442f
C1105 w_9880_11630.t2 VSUB 0.29442f
C1106 w_9880_11630.n0 VSUB 0.81877f
C1107 w_9880_11630.t0 VSUB 0.28183f
C1108 w_9880_11630.n1 VSUB 1.75447f
C1109 w_9880_11630.t5 VSUB 1.68626f
C1110 w_9880_11630.n8 VSUB 0.01612f
C1111 w_9880_11630.n9 VSUB 0.01121f
C1112 w_9880_11630.n17 VSUB 0.01612f
C1113 w_9880_11630.n18 VSUB 0.01121f
C1114 w_9880_11630.n26 VSUB 0.01612f
C1115 w_9880_11630.n27 VSUB 0.01121f
C1116 w_9880_11630.n41 VSUB 0.01132f
C1117 w_9880_11630.n56 VSUB 0.01612f
C1118 w_9880_11630.n57 VSUB 0.01121f
C1119 w_9880_11630.n73 VSUB 0.01132f
C1120 w_9880_11630.n107 VSUB 0.01132f
C1121 w_9880_11630.n123 VSUB 0.01132f
C1122 w_9880_11630.n137 VSUB 0.10728f
C1123 w_9880_11630.n138 VSUB 1.29744f
C1124 w_9880_11630.t4 VSUB 66.0701f
C1125 w_9880_11630.n139 VSUB 1.74242f
C1126 w_9880_11630.t1 VSUB 0.5562f
C1127 w_12740_11630.t2 VSUB 0.26332f
C1128 w_12740_11630.n0 VSUB 0.76501f
C1129 w_12740_11630.t0 VSUB 0.27509f
C1130 w_12740_11630.t1 VSUB 0.27509f
C1131 w_12740_11630.n1 VSUB 1.27204f
C1132 w_12740_11630.n2 VSUB 0.2511f
C1133 w_12740_11630.n11 VSUB 0.01047f
C1134 w_12740_11630.n13 VSUB 0.01047f
C1135 w_12740_11630.n26 VSUB 0.01506f
C1136 w_12740_11630.t6 VSUB 1.57551f
C1137 w_12740_11630.n31 VSUB 0.01057f
C1138 w_12740_11630.n45 VSUB 0.01057f
C1139 w_12740_11630.n64 VSUB 0.01506f
C1140 w_12740_11630.n65 VSUB 0.01506f
C1141 w_12740_11630.n66 VSUB 0.01047f
C1142 w_12740_11630.n68 VSUB 0.01057f
C1143 w_12740_11630.n80 VSUB 0.01057f
C1144 w_12740_11630.n82 VSUB 0.01047f
C1145 w_12740_11630.n135 VSUB 0.01506f
C1146 w_12740_11630.n138 VSUB 1.60284f
C1147 w_12740_11630.t3 VSUB 62.0382f
C1148 w_12740_11630.t5 VSUB 1.76383f
C1149 w_12740_11630.n139 VSUB 1.43601f
C1150 w_12740_11630.t4 VSUB 1.76496f
C1151 w_12740_11630.n140 VSUB 1.03357f
C1152 w_12740_8770.t3 VSUB 38.612f
C1153 w_12740_8770.t5 VSUB 0.13409p
C1154 w_12740_8770.t1 VSUB 0.60118f
C1155 w_12740_8770.n0 VSUB 1.32083f
C1156 w_12740_8770.t0 VSUB 0.60118f
C1157 w_12740_8770.n1 VSUB 0.86616f
C1158 w_12740_8770.t2 VSUB 1.17308f
C1159 w_12740_8770.n2 VSUB 1.87232f
C1160 w_12740_8770.t6 VSUB 1.70153f
C1161 w_12740_8770.n9 VSUB 0.01626f
C1162 w_12740_8770.n10 VSUB 0.01131f
C1163 w_12740_8770.n18 VSUB 0.01626f
C1164 w_12740_8770.n19 VSUB 0.01131f
C1165 w_12740_8770.n27 VSUB 0.01626f
C1166 w_12740_8770.n28 VSUB 0.01131f
C1167 w_12740_8770.n42 VSUB 0.01142f
C1168 w_12740_8770.n57 VSUB 0.01626f
C1169 w_12740_8770.n58 VSUB 0.01131f
C1170 w_12740_8770.n74 VSUB 0.01142f
C1171 w_12740_8770.n108 VSUB 0.01142f
C1172 w_12740_8770.n124 VSUB 0.01142f
C1173 w_12740_8770.n138 VSUB 0.30752f
C1174 w_12740_8770.n139 VSUB 2.59872f
C1175 w_12740_8770.n140 VSUB 1.89084f
C1176 w_12740_8770.t4 VSUB 0.39594f
C1177 ndl.t0 VSUB 0.49291f
C1178 ndl.t2 VSUB 2.37626f
C1179 ndl.t1 VSUB 3.77561f
C1180 ndl.t3 VSUB 3.77741f
C1181 ndl.n0 VSUB 2.17495f
C1182 nsv.t2 VSUB 0.35098f
C1183 nsv.t0 VSUB 0.45843f
C1184 nsv.n0 VSUB 2.34628f
C1185 nsv.t1 VSUB 3.40459f
C1186 nsv.t4 VSUB 5.38763f
C1187 nsv.t3 VSUB 5.39096f
C1188 nsv.n1 VSUB 5.8591f
C1189 out.t0 VSUB 0.87384f
C1190 out.t1 VSUB 5.37283f
C1191 out.n0 VSUB 3.7441f
C1192 out.t2 VSUB 2.74646f
C1193 out.n1 VSUB 3.60802f
C1194 vrefb.t3 VSUB 4.2951f
C1195 vrefb.t2 VSUB 4.29786f
C1196 vrefb.n0 VSUB 2.14165f
C1197 vrefb.t0 VSUB 0.19302f
C1198 vrefb.t1 VSUB 0.18549f
C1199 vrefb.n1 VSUB 2.68917f
C1200 vrefb.n2 VSUB 3.41424f
C1201 vrefb.t5 VSUB 4.2951f
C1202 vrefb.t4 VSUB 4.29786f
C1203 vrefb.n3 VSUB 2.29863f
C1204 vrefb.n4 VSUB 1.32876f
C1205 a_13717_18364.t1 VSUB 0.56845f
C1206 a_13717_18364.t0 VSUB 0.56845f
C1207 a_13100_15680.t3 VSUB 0.26639f
C1208 a_13100_15680.n0 VSUB 0.77393f
C1209 a_13100_15680.t0 VSUB 0.2783f
C1210 a_13100_15680.t2 VSUB 0.2783f
C1211 a_13100_15680.t1 VSUB 36.634f
C1212 a_13100_15680.n1 VSUB 2.57841f
C1213 a_13100_15680.t4 VSUB 0.1331f
C1214 a_13100_15680.n2 VSUB 1.91564f
C1215 nu.t0 VSUB 0.22731f
C1216 nu.t1 VSUB 62.1709f
C1217 nu.t3 VSUB 1.77479f
C1218 nu.t2 VSUB 1.77589f
C1219 nu.n0 VSUB 1.58907f
C1220 nu.n1 VSUB 2.06423f
C1221 a_14221_18364.t1 VSUB 0.6584f
C1222 a_14221_18364.t0 VSUB 0.6584f
C1223 a_14725_18364.t1 VSUB 0.59601f
C1224 a_14725_18364.t0 VSUB 0.59601f
C1225 a_15733_18364.t1 VSUB 0.51249f
C1226 a_15733_18364.t0 VSUB 0.51249f
C1227 a_16237_18364.t1 VSUB 0.57402f
C1228 a_16237_18364.t0 VSUB 0.57402f
C1229 a_16741_18364.t1 VSUB 0.5219f
C1230 a_16741_18364.t0 VSUB 0.5219f
C1231 a_1400_10660.t0 VSUB 0.58061f
C1232 a_1400_10660.n0 VSUB 1.69959f
C1233 a_1400_10660.n1 VSUB 1.59723f
C1234 a_1400_10660.t3 VSUB 0.58061f
C1235 a_1400_10660.t1 VSUB 0.58061f
C1236 a_1400_10660.n2 VSUB 4.83882f
C1237 a_1400_10660.t2 VSUB 2.42942f
C1238 a_1400_10660.t4 VSUB 0.58061f
C1239 a_380_8760.t3 VSUB 0.36785f
C1240 a_380_8760.n0 VSUB 1.24453f
C1241 a_380_8760.t0 VSUB 0.42259f
C1242 a_380_8760.t1 VSUB 0.42259f
C1243 a_380_8760.t2 VSUB 0.81584f
C1244 a_380_8760.n1 VSUB 0.72106f
C1245 a_380_8760.t4 VSUB 0.81584f
C1246 a_380_8760.n2 VSUB 1.30041f
C1247 a_5880_10660.t0 VSUB 2.30239f
C1248 a_5880_10660.n0 VSUB 1.61068f
C1249 a_5880_10660.t4 VSUB 0.55025f
C1250 a_5880_10660.t1 VSUB 0.55025f
C1251 a_5880_10660.n1 VSUB 1.51369f
C1252 a_5880_10660.t2 VSUB 0.55025f
C1253 a_5880_10660.t3 VSUB 0.55025f
C1254 a_5880_10660.n2 VSUB 4.58571f
C1255 a_4860_8760.t3 VSUB 0.42146f
C1256 a_4860_8760.n0 VSUB 1.42589f
C1257 a_4860_8760.t0 VSUB 0.48418f
C1258 a_4860_8760.t1 VSUB 0.48418f
C1259 a_4860_8760.t2 VSUB 0.93472f
C1260 a_4860_8760.n1 VSUB 0.82613f
C1261 a_4860_8760.t4 VSUB 0.93472f
C1262 a_4860_8760.n2 VSUB 1.48992f
C1263 ve.n0 VSUB -4.87444f
C1264 ve.t0 VSUB 5.35344f
C1265 ve.t1 VSUB 0.42041f
C1266 ve.n1 VSUB 3.84159f
C1267 ve.t3 VSUB 0.17811f
C1268 ve.t4 VSUB 0.17811f
C1269 ve.n2 VSUB 0.63272f
C1270 ve.t5 VSUB 0.17811f
C1271 ve.t2 VSUB 0.17811f
C1272 ve.n3 VSUB 0.547f
C1273 ve.n4 VSUB 3.22783f
C1274 ve.n5 VSUB 0.96987f
C1275 a_2374_3250.t3 VSUB 0.47742f
C1276 a_2374_3250.n0 VSUB 1.31335f
C1277 a_2374_3250.n1 VSUB 1.3975f
C1278 a_2374_3250.t2 VSUB 0.47742f
C1279 a_2374_3250.t1 VSUB 0.47742f
C1280 a_2374_3250.t4 VSUB 1.99762f
C1281 a_2374_3250.n2 VSUB 3.97878f
C1282 a_2374_3250.t0 VSUB 0.47742f
C1283 a_600_1350.t3 VSUB 0.42264f
C1284 a_600_1350.n0 VSUB 1.49214f
C1285 a_600_1350.t1 VSUB 0.48723f
C1286 a_600_1350.t0 VSUB 0.48723f
C1287 a_600_1350.t2 VSUB 0.94056f
C1288 a_600_1350.n1 VSUB 0.81516f
C1289 a_600_1350.t4 VSUB 0.94056f
C1290 a_600_1350.n2 VSUB 1.60909f
C1291 a_1840_1350.t0 VSUB 0.37404f
C1292 a_1840_1350.n0 VSUB 1.19225f
C1293 a_1840_1350.t2 VSUB 0.42617f
C1294 a_1840_1350.t3 VSUB 0.42617f
C1295 a_1840_1350.n1 VSUB 1.22354f
C1296 a_1840_1350.t1 VSUB 0.10693p
C1297 a_1840_1350.t5 VSUB 0.6955f
C1298 a_1840_1350.n2 VSUB 0.72918f
C1299 a_1840_1350.t4 VSUB 0.69608f
C1300 a_1840_1350.n3 VSUB 1.30604f
C1301 a_14480_2450.t0 VSUB 0.41862f
C1302 a_14480_2450.n0 VSUB 1.2254f
C1303 a_14480_2450.n1 VSUB 1.1516f
C1304 a_14480_2450.t2 VSUB 0.41862f
C1305 a_14480_2450.t1 VSUB 0.41862f
C1306 a_14480_2450.n2 VSUB 3.48877f
C1307 a_14480_2450.t3 VSUB 1.7516f
C1308 a_14480_2450.t4 VSUB 0.41862f
C1309 a_13460_550.t3 VSUB 0.22603f
C1310 a_13460_550.n0 VSUB 0.7647f
C1311 a_13460_550.t0 VSUB 0.25966f
C1312 a_13460_550.t1 VSUB 0.25966f
C1313 a_13460_550.t2 VSUB 0.50129f
C1314 a_13460_550.n1 VSUB 0.44305f
C1315 a_13460_550.t4 VSUB 0.50129f
C1316 a_13460_550.n2 VSUB 0.79903f
.ends
