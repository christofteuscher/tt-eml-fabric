* ln-path slope of the LAYOUT ota1vb (not the ideal-buffer schematic).
.lib /Users/cteusche/.ciel/sky130A/libs.tech/ngspice/sky130.lib.spice tt
.include _v2d_lay.inc
.control
set noaskquit
alter @IUIN[dc] = 0
let vv = 0.25
dowhile vv <= 4.001
  alter @IV[dc] = 0.5u*vv
  op
  let io = i(VOUT)/0.5u
  print vv io
  let vv = vv * 1.4142136
end
.endc
.end
