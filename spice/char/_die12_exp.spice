* USABLE INPUT RANGE (buffered servo, IBUF 0.55u) -- measured deviation
* from a true 1 - ln(v):
*
*     v      error (units)      verdict
*    0.25      -0.213           OUT OF RANGE
*    0.35      +0.101
*    0.50      +0.126           degraded
*    0.71      +0.084
*    1.00      +0.043
*    1.41      +0.011           good
*    2.00      -0.015
*    2.83      -0.034
*    4.00      -0.049
*
*   v >= 1.0     |error| <= 0.05 units   RECOMMENDED
*   v >= 0.35    |error| <= 0.13 units   usable, degraded
*   v <  0.35    error grows fast        AVOID
*
* The floor is a LOW-CURRENT effect, not a topology one: at v=0.25 the
* transdiode carries 0.125 uA, where beta falls away (measured ~29 at
* 0.5 uA), so the loading and the follower's operating point both shift in
* a region a fixed IBUF cannot track.  Above v=1 the buffered servo holds
* the collector to 1.1 mV per octave against 9.7 mV unbuffered.
*
* NOTE this range describes the BUFFERED REDESIGN, which is schematic-only.
* The SHIPPED part (ttsky26c-submitted-v1) has the unbuffered servo and a
* ln coefficient of ~-0.34 across the WHOLE range -- see docs/info.md in
* tt-eml-fabric.  Do not quote these numbers for the fabricated chip.
*
* CELL ACCURACY ON THE LAYOUT-MATCHED NETLIST (not the schematic).
*
* eml_accuracy.spice measures ../cell/v2d_core.inc -- the SCHEMATIC cell.
* This runs the same method against emlcell_b_sim.inc, which is
* lvsref/emlcell_b_flat.spice with M/Q/R primitive cards rewritten as
* X-cards (sky130's ngspice devices are .subckt, so the LVS card forms do
* not bind).  Nothing else is changed: that netlist LVS-MATCHES the shipped
* emlcell_b layout, so this is the topology and device sizing on the die.
*
* WHY NOT MAGIC'S EXTRACTION.  emlcell_b_flat_rc.spice cannot be used: all
* 20 of its poly-resistor cards come out with BOTH TERMINALS ON THE SAME
* NODE (e.g. "X23 nv nv VSUB ... w=0.175 l=0.355" for a device that is
* 0.35 x 14.72 um).  Magic's fixed-width res_high_po_0p35 recognition needs
* a uniform-width poly strip and emlcell_b's resistors have WIDER CONTACT
* PADS at the ends, so it falls back to a generic model and cannot pair the
* terminals.  The layout is fine -- poly measures 0.350 at 2%, 50% and 98%
* of the strip, DRC is 0 and LVS MATCHes -- but that netlist would simulate
* every 100k resistor as a short.  The reference carries them correctly:
*   RU_0  vb2 nu    VSUB  res_high_po_0p35   L=58.88u W=0.35u
*   RSA_0 nv  vrefb VSUB  res_xhigh_po_0p35  L=17.5u  W=0.35u
* SO THIS IS SCHEMATIC-LEVEL SIZING WITH LAYOUT-VERIFIED TOPOLOGY, NOT a
* parasitic-annotated run.  Metal R/C are NOT included.
*
* Method follows eml_accuracy.spice so the numbers are comparable: VOUT
* holds `out` at 0.9 V so i(VOUT) is the output current, u enters as a
* current into nu, and v is held at 1 unit -- which means the ln term is
* zero and this exercises the EXP path only, the same blind spot the
* schematic bench has.
*
* Run: cd char && ngspice -b eml_layout_accuracy.spice
.lib $PDK_ROOT/sky130A/libs.tech/ngspice/sky130.lib.spice tt
.include emlcell_b_sim12.inc

.param iunit=0.5u

VDD  vdd   0 3.3
VRB  vrefb 0 1.2
VE   ve    0 0.55
VOUT out   0 0.9

* HARNESS: FEWER EXTERNAL SOURCES THAN THE SCHEMATIC BENCH, NOT MORE.
* cell/v2d_core.inc drives IR1 into nb0, IOFF2 into nsv and IOFF3 into out
* from IDEAL current sources.  Copying that here was wrong: the LAYOUT cell
* generates those legs INTERNALLY off pbias -- gen_topnets.py notes
* "emlcell_b carries its OWN pedestal on nv (XLPA W=8 L=8)".  Injecting them
* a second time DOUBLED the output (io(0) 1.084 -> 2.125) while the
* schematic reference gives 1.048.  A second tell: v2d_core also drives
* IVR into the ln reference leg nvb, and nvb is not a pin even in the
* 12-port reference -- because on silicon it is generated inside.
* So the external drive is: supplies, the two references, u and v.
*
* pbias mirror geometry must match the cell's own load (XLR1 L=8 W=4);
* at W=8 L=2 the mirrored current is 8x off and the output collapses.
IPB  pbias 0 {iunit}
XPB  pbias pbias vdd vdd sky130_fd_pr__pfet_g5v0d10v5 L=8 W=4

* v = 1 unit (ln term zero); u swept by the control block
IVIN 0 nv {iunit}
IUIN 0 nu 0

* nsv and out take the ln path's +4-unit operating offset FROM OUTSIDE the
* cell -- both are pins, and on silicon those units arrive from the MDAC /
* glue.  nb0 is NOT injected: the cell generates it internally off pbias,
* and injecting it doubled the exp output.  The three are not equivalent
* and removing all three together is what hid this.
IOFF2 vdd nsv {4*iunit}
IOFF3 vdd out {4*iunit}
XDUT nu nv out vdd vrefb ve pbias 0 nb0 nc2 ndl nsv emlcell_b

.control
set noaskquit
alter @IVIN[dc] = 0.5u
alter @IUIN[dc] = -5.000000e-07
op
let io = i(VOUT)/0.5u
print io
alter @IUIN[dc] = -4.375000e-07
op
let io = i(VOUT)/0.5u
print io
alter @IUIN[dc] = -3.750000e-07
op
let io = i(VOUT)/0.5u
print io
alter @IUIN[dc] = -3.125000e-07
op
let io = i(VOUT)/0.5u
print io
alter @IUIN[dc] = -2.500000e-07
op
let io = i(VOUT)/0.5u
print io
alter @IUIN[dc] = -1.875000e-07
op
let io = i(VOUT)/0.5u
print io
alter @IUIN[dc] = -1.250000e-07
op
let io = i(VOUT)/0.5u
print io
alter @IUIN[dc] = -6.250000e-08
op
let io = i(VOUT)/0.5u
print io
alter @IUIN[dc] = 0.000000e+00
op
let io = i(VOUT)/0.5u
print io
alter @IUIN[dc] = 6.250000e-08
op
let io = i(VOUT)/0.5u
print io
alter @IUIN[dc] = 1.250000e-07
op
let io = i(VOUT)/0.5u
print io
alter @IUIN[dc] = 1.875000e-07
op
let io = i(VOUT)/0.5u
print io
alter @IUIN[dc] = 2.500000e-07
op
let io = i(VOUT)/0.5u
print io
alter @IUIN[dc] = 3.125000e-07
op
let io = i(VOUT)/0.5u
print io
alter @IUIN[dc] = 3.750000e-07
op
let io = i(VOUT)/0.5u
print io
alter @IUIN[dc] = 4.375000e-07
op
let io = i(VOUT)/0.5u
print io
alter @IUIN[dc] = 5.000000e-07
op
let io = i(VOUT)/0.5u
print io
alter @IUIN[dc] = 5.625000e-07
op
let io = i(VOUT)/0.5u
print io
alter @IUIN[dc] = 6.250000e-07
op
let io = i(VOUT)/0.5u
print io
alter @IUIN[dc] = 6.875000e-07
op
let io = i(VOUT)/0.5u
print io
alter @IUIN[dc] = 7.500000e-07
op
let io = i(VOUT)/0.5u
print io
.endc
.end
