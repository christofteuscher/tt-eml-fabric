* All four emlcell_b poly resistors, 0.5 uA forced, DC.
.lib $PDK_ROOT/sky130A/libs.tech/ngspice/sky130.lib.spice tt
VB1 b1 0 0.7
I1 b1 a1 0.5u
XRU a1 b1 0 sky130_fd_pr__res_high_po_0p35  L=58.88 W=0.35
VB2 b2 0 0.7
I2 b2 a2 0.5u
XRLN a2 b2 0 sky130_fd_pr__res_high_po_0p35 L=58.88 W=0.35
VB3 b3 0 0.7
I3 b3 a3 0.5u
XRSA a3 b3 0 sky130_fd_pr__res_xhigh_po_0p35 L=17.5 W=0.35
.control
set noaskquit
op
let ru  = (v(a1)-v(b1))/0.5u
let rln = (v(a2)-v(b2))/0.5u
let rsa = (v(a3)-v(b3))/0.5u
print ru rln rsa
.endc
.end
