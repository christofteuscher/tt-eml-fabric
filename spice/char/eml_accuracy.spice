* CELL-LEVEL ACCURACY: the fabric cell against ideal exp(u) - ln(v).
*
* The first bench of its kind here -- char/ previously had only device-level
* (npn_gummel, nfet_subvt, mirror_mc) and OTA-level (ota_shrink_*) sweeps, so
* nothing measured what the CELL actually computes.  Results in
* ../EMLCELL_ANALYSIS.md.
*
* Method: VOUT holds `out` at 0.9 V, so i(VOUT) is the cell output current.
* u enters as IUIN = -u*IUNIT (the TIA inverts).  v is fixed at 1 here, so
* the ln term is zero and this exercises the EXP path only -- the ln path
* and two of its three servos are barely stimulated.  Extending this to the
* 2-D (u,v) surface is the largest remaining gap in the characterisation.
*
* Baseline result (tt, 27 C, v=1): +1.55% .. +5.07%, rms 3.85%.
*
* Run: cd char && ngspice -b eml_accuracy.spice
.lib $PDK_ROOT/sky130A/libs.tech/ngspice/sky130.lib.spice tt
.include ../cell/v2d_core.inc
.control
set noaskquit
let uu = -1.5
dowhile uu <= 1.5001
  alter @IUIN[dc] = -0.5u*uu
  op
  let io    = i(VOUT)/0.5u
  let ideal = exp(uu)
  print uu io ideal
  let uu = uu + 0.25
end
.endc
.end
