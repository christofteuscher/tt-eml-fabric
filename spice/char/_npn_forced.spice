* DECISIVE: base and collector SEPARATED (as in the cell), collector
* currents forced in exact ratio, bases driven by IDEAL servos.
.lib /Users/cteusche/.ciel/sky130A/libs.tech/ngspice/sky130.lib.spice tt
VE   ve   0 0.55
VREF vref 0 1.20
VDDA vdda 0 3.3
IA vdda a 0.5u
EA  bax 0 a vref 1e6
VOA ba bax DC 1.25
XQA a ba ve 0 sky130_fd_pr__npn_05v5_W1p00L1p00
VDDB vddb 0 3.3
IB vddb b 0.5u
EB  bbx 0 b vref 1e6
VOB bb bbx DC 1.25
XQB b bb ve 0 sky130_fd_pr__npn_05v5_W1p00L1p00
.control
set noaskquit
foreach r 1 2 4 8
  alter @IA[dc] = $r*0.5u
  op
  echo RATIO $r
  print v(ba)
  print v(bb)
  print v(a)
end
.endc
.end
